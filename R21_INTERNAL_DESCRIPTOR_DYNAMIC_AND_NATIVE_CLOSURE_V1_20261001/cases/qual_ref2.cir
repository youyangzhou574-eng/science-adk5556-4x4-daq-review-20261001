VCM VEXC local descriptor qualification
.include "E:\open\SCIENCE_ADK5556_4X4_DAQ_REPLICA\R21_INTERNAL_DESCRIPTOR_DYNAMIC_AND_NATIVE_CLOSURE_V1\models\OPAx388.LIB"
V5 v5 0 5
VREF ref 0 2.5
VTEST cmminus cmfb DC 0 AC 1
RCM_IN ref vcm_cmd 1k
XCM vcm_cmd cmminus v5 0 cmdrv OPAx388
RCMISO cmdrv vcm 1k
RCMFB vcm cmfb 4.99k
CCMHF cmdrv cmfb 100p
CCML vcm 0 1n
RUP vcm vexcmd 10k
RDN vexcmd 0 90k
XEX vexcmd exfb v5 0 exdrv OPAx388
REXISO exdrv vexc 1k
REXFB vexc exfb 4.99k
CEXHF exdrv exfb 100p
CEXL vexc 0 1n
RCML vcm 0 1meg
REXL vexc 0 1meg

.save all
.control
set filetype=ascii
set numdgt=15
set wr_singlescale
set wr_vecnames
op
write op.raw all
listing e
ac lin 1 0.01 0.01
wrdata ac_00.txt v(cmminus) v(cmfb) v(cmdrv) v(vcm) v(exdrv) v(vexc)
ac lin 1 0.1 0.1
wrdata ac_01.txt v(cmminus) v(cmfb) v(cmdrv) v(vcm) v(exdrv) v(vexc)
ac lin 1 1 1
wrdata ac_02.txt v(cmminus) v(cmfb) v(cmdrv) v(vcm) v(exdrv) v(vexc)
ac lin 1 10 10
wrdata ac_03.txt v(cmminus) v(cmfb) v(cmdrv) v(vcm) v(exdrv) v(vexc)
ac lin 1 100 100
wrdata ac_04.txt v(cmminus) v(cmfb) v(cmdrv) v(vcm) v(exdrv) v(vexc)
ac lin 1 1000 1000
wrdata ac_05.txt v(cmminus) v(cmfb) v(cmdrv) v(vcm) v(exdrv) v(vexc)
ac lin 1 10000 10000
wrdata ac_06.txt v(cmminus) v(cmfb) v(cmdrv) v(vcm) v(exdrv) v(vexc)
ac lin 1 100000 100000
wrdata ac_07.txt v(cmminus) v(cmfb) v(cmdrv) v(vcm) v(exdrv) v(vexc)
ac lin 1 1e+06 1e+06
wrdata ac_08.txt v(cmminus) v(cmfb) v(cmdrv) v(vcm) v(exdrv) v(vexc)
ac lin 1 1e+07 1e+07
wrdata ac_09.txt v(cmminus) v(cmfb) v(cmdrv) v(vcm) v(exdrv) v(vexc)
ac lin 1 1e+08 1e+08
wrdata ac_10.txt v(cmminus) v(cmfb) v(cmdrv) v(vcm) v(exdrv) v(vexc)
ac lin 1 3e+08 3e+08
wrdata ac_11.txt v(cmminus) v(cmfb) v(cmdrv) v(vcm) v(exdrv) v(vexc)
ac dec 50 1 300meg
wrdata dense.txt v(cmminus) v(cmfb) v(cmdrv) v(vcm) v(exdrv) v(vexc)
quit
.endc
.end
