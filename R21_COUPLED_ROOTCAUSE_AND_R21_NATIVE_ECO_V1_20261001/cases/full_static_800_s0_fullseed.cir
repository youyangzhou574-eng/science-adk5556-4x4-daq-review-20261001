full_static_800_s0_fullseed
.include "../../models/OPA4388_ORIGINAL.LIB"
.include "../../models/OPAx388.LIB"
V5 v5 0 5
VREF ref 0 DC 2.5 AC 1
RCM_IN ref vcm_cmd 1k
XCM vcm_cmd cmfb v5 0 cmdrv OPAx388
RCMISO cmdrv vcm 1k
RCMFB vcm cmfb 4.99k
CCMHF cmdrv cmfb 100p
CCML vcm 0 1n
RUP vcm vexcmd 10k
RDN vexcmd 0 90k
XEX vexcmd exfb v5 0 exdrv OPAx388
REXISO exdrv vexc 1k
REXFB vexc exfb 4.99k
CEXHF exdrv exfb 100p
CEXL vexc 0 1n
.model MUX SW(Ron=5 Roff=1e12 Vt=.5 Vh=.1)
VSEL0 sel0 0 1
BNS0 ns0 0 V=1-V(sel0)
SA0 vexc cmd0 sel0 0 MUX
SB0 vcm cmd0 ns0 0 MUX
XR0 cmd0 fb0 v5 0 drv0 OPA4388
RISO0 drv0 row0 1k
RFB0 row0 fb0 4.99k
CHF0 drv0 fb0 100p
CLROW0 row0 0 1n
VSEL1 sel1 0 0
BNS1 ns1 0 V=1-V(sel1)
SA1 vexc cmd1 sel1 0 MUX
SB1 vcm cmd1 ns1 0 MUX
XR1 cmd1 fb1 v5 0 drv1 OPA4388
RISO1 drv1 row1 1k
RFB1 row1 fb1 4.99k
CHF1 drv1 fb1 100p
CLROW1 row1 0 1n
VSEL2 sel2 0 0
BNS2 ns2 0 V=1-V(sel2)
SA2 vexc cmd2 sel2 0 MUX
SB2 vcm cmd2 ns2 0 MUX
XR2 cmd2 fb2 v5 0 drv2 OPA4388
RISO2 drv2 row2 1k
RFB2 row2 fb2 4.99k
CHF2 drv2 fb2 100p
CLROW2 row2 0 1n
VSEL3 sel3 0 0
BNS3 ns3 0 V=1-V(sel3)
SA3 vexc cmd3 sel3 0 MUX
SB3 vcm cmd3 ns3 0 MUX
XR3 cmd3 fb3 v5 0 drv3 OPA4388
RISO3 drv3 row3 1k
RFB3 row3 fb3 4.99k
CHF3 drv3 fb3 100p
CLROW3 row3 0 1n
XT0 vcm minus0 v5 0 tdrv0 OPA4388
RSENSE0 col0 minus0 10k
RTISO0 tdrv0 tap0 1k
RF0 tap0 col0 4.99k
CF0 tap0 col0 2.2n
CHFT0 tdrv0 minus0 22p
RADC0 tap0 ain0 100
CADC0 ain0 0 10n
RIN0 ain0 0 1meg
CLCOL0 col0 0 1n
RA0_0 row0 col0 800
RA1_0 row1 col0 800
RA2_0 row2 col0 800
RA3_0 row3 col0 800
XT1 vcm minus1 v5 0 tdrv1 OPA4388
RSENSE1 col1 minus1 10k
RTISO1 tdrv1 tap1 1k
RF1 tap1 col1 4.99k
CF1 tap1 col1 2.2n
CHFT1 tdrv1 minus1 22p
RADC1 tap1 ain1 100
CADC1 ain1 0 10n
RIN1 ain1 0 1meg
CLCOL1 col1 0 1n
RA0_1 row0 col1 800
RA1_1 row1 col1 800
RA2_1 row2 col1 800
RA3_1 row3 col1 800
XT2 vcm minus2 v5 0 tdrv2 OPA4388
RSENSE2 col2 minus2 10k
RTISO2 tdrv2 tap2 1k
RF2 tap2 col2 4.99k
CF2 tap2 col2 2.2n
CHFT2 tdrv2 minus2 22p
RADC2 tap2 ain2 100
CADC2 ain2 0 10n
RIN2 ain2 0 1meg
CLCOL2 col2 0 1n
RA0_2 row0 col2 800
RA1_2 row1 col2 800
RA2_2 row2 col2 800
RA3_2 row3 col2 800
XT3 vcm minus3 v5 0 tdrv3 OPA4388
RSENSE3 col3 minus3 10k
RTISO3 tdrv3 tap3 1k
RF3 tap3 col3 4.99k
CF3 tap3 col3 2.2n
CHFT3 tdrv3 minus3 22p
RADC3 tap3 ain3 100
CADC3 ain3 0 10n
RIN3 ain3 0 1meg
CLCOL3 col3 0 1n
RA0_3 row0 col3 800
RA1_3 row1 col3 800
RA2_3 row2 col3 800
RA3_3 row3 col3 800
.save v(vcm) v(vexc) v(vexcmd) v(cmdrv) v(exdrv) v(row0) v(row1) v(row2) v(row3) v(col0) v(col1) v(col2) v(col3) v(drv0) v(drv1) v(drv2) v(drv3) v(tdrv0) v(tdrv1) v(tdrv2) v(tdrv3) v(tap0) v(tap1) v(tap2) v(tap3) v(ain0) v(ain1) v(ain2) v(ain3)
.options method=trap
.nodeset v(v5)=5
.nodeset v(ain0)=4.058965783109764
.nodeset v(ain1)=4.058965783036155
.nodeset v(ain2)=4.058965783109764
.nodeset v(ain3)=4.058965783086281
.nodeset v(cmd0)=2.500000015098415
.nodeset v(cmd1)=2.249999778987949
.nodeset v(cmd2)=2.500000015098421
.nodeset v(cmd3)=2.500000015099661
.nodeset v(cmdrv)=2.525000222243037
.nodeset v(cmfb)=2.500000169005621
.nodeset v(col0)=2.5000012570635
.nodeset v(col1)=2.5000012570635
.nodeset v(col2)=2.5000012570635
.nodeset v(col3)=2.5000012570635
.nodeset v(drv0)=2.500002600477872
.nodeset v(drv1)=1.000001355926879
.nodeset v(drv2)=2.500002600245118
.nodeset v(drv3)=2.500002601962559
.nodeset v(exdrv)=2.249999775022906
.nodeset v(exfb)=2.249999938718031
.nodeset v(fb0)=2.500001639888858
.nodeset v(fb1)=2.250001438509647
.nodeset v(fb2)=2.50000163986007
.nodeset v(fb3)=2.500001640135915
.nodeset v(minus0)=2.500001565345199
.nodeset v(minus1)=2.500001565345199
.nodeset v(minus2)=2.500001565345199
.nodeset v(minus3)=2.500001565345199
.nodeset v(ns0)=1
.nodeset v(ns1)=0
.nodeset v(ns2)=1
.nodeset v(ns3)=1
.nodeset v(ref)=2.5
.nodeset v(row0)=2.500001486105029
.nodeset v(row1)=2.250001278896562
.nodeset v(row2)=2.500001486076239
.nodeset v(row3)=2.500001486352098
.nodeset v(sel0)=0
.nodeset v(sel1)=1
.nodeset v(sel2)=0
.nodeset v(sel3)=0
.nodeset v(tap0)=4.059371679688075
.nodeset v(tap1)=4.059371679614458
.nodeset v(tap2)=4.059371679688075
.nodeset v(tap3)=4.059371679664589
.nodeset v(tdrv0)=4.375929728161479
.nodeset v(tdrv1)=4.375929728073035
.nodeset v(tdrv2)=4.375929728161479
.nodeset v(tdrv3)=4.375929728133263
.nodeset v(vcm)=2.500000015250407
.nodeset v(vcm_cmd)=2.49999997008045
.nodeset v(vexc)=2.249999779131118
.nodeset v(vexcmd)=2.249999753991658
.nodeset v(xcm.cl_clamp)=2.525003226268534
.nodeset v(xcm.clamp)=2.525008769589476
.nodeset v(xcm.claw_clamp)=2.525003226268771
.nodeset v(xcm.esdn)=2.500000169005929
.nodeset v(xcm.esdp)=2.499999970080151
.nodeset v(xcm.mid)=2.499998749999496
.nodeset v(xcm.n2991553)=2.499998749999619
.nodeset v(xcm.n2991555)=2.499999669878151
.nodeset v(xcm.n2991563)=2.49999966993739
.nodeset v(xcm.n2991573)=2.499999970080151
.nodeset v(xcm.n2991579)=2.499998499872028
.nodeset v(xcm.n2991581)=2.499999000056634
.nodeset v(xcm.n2991583)=2.49999966993739
.nodeset v(xcm.n2991587)=2.500000170121995
.nodeset v(xcm.n2991619)=2.500000169005929
.nodeset v(xcm.n2991623)=5.099997499998896
.nodeset v(xcm.n2991635)=-0.09999750000115196
.nodeset v(xcm.n2991643)=2.500000170122139
.nodeset v(xcm.n2991657)=2.500000170122139
.nodeset v(xcm.n2991667)=2.499998849565686
.nodeset v(xcm.n2991729)=2.499998749999496
.nodeset v(xcm.n2991741)=2.499998749999496
.nodeset v(xcm.n2991763)=2.499998749999496
.nodeset v(xcm.n2991765)=2.499998749999496
.nodeset v(xcm.n2991807)=62.4999987499995
.nodeset v(xcm.n2991809)=2.499998749999641
.nodeset v(xcm.n2991811)=2.499998749999641
.nodeset v(xcm.n2991831)=2.499998749999641
.nodeset v(xcm.n2991837)=2.499998749999641
.nodeset v(xcm.n2991849)=-57.5000012500005
.nodeset v(xcm.n2991901)=152.4999987499995
.nodeset v(xcm.n2991905)=2.499998749999641
.nodeset v(xcm.n2991907)=2.499998749999641
.nodeset v(xcm.n2991925)=2.499998749999641
.nodeset v(xcm.n2991931)=2.499998749999641
.nodeset v(xcm.n2991943)=-147.5000012500005
.nodeset v(xcm.n2991969)=2.525008769649185
.nodeset v(xcm.n2991997)=4.984888921615235
.nodeset v(xcm.n2992001)=0.02308224848019233
.nodeset v(xcm.n2992029)=0.02308224848019233
.nodeset v(xcm.n2992033)=4.984888921615235
.nodeset v(xcm.n2992093)=2.499998694889493
.nodeset v(xcm.n2992099)=2.4999986948895
.nodeset v(xcm.n2992105)=2.499998749999496
.nodeset v(xcm.n2992151)=2.524998957092127
.nodeset v(xcm.n2992163)=2.525000222243037
.nodeset v(xcm.n2992235)=2.525000222243037
.nodeset v(xcm.n2992267)=-52.47499671862145
.nodeset v(xcm.n2992287)=57.52500317115855
.nodeset v(xcm.n2992295)=-52.47499677373146
.nodeset v(xcm.n2992299)=-52.47499671862145
.nodeset v(xcm.n2992323)=57.52500317115855
.nodeset v(xcm.n2992331)=57.52500322626854
.nodeset v(xcm.n2992375)=2.499998749999496
.nodeset v(xcm.n2992397)=4.999997497498897
.nodeset v(xcm.n2992413)=2.502498844290287e-06
.nodeset v(xcm.n3201092)=3.21326728370102
.nodeset v(xcm.n3294524)=2.525003226268771
.nodeset v(xcm.n3294618)=2.525003226268534
.nodeset v(xcm.n3294626)=3.213267242603171
.nodeset v(xcm.n3294630)=2.839650432714508
.nodeset v(xcm.n3294682)=3.212518568764608
.nodeset v(xcm.n3294772)=2.499998750042431
.nodeset v(xcm.n3294776)=2.499998749999619
.nodeset v(xcm.n3827259)=3.213127902811133
.nodeset v(xcm.n3828449)=2.500568797283919
.nodeset v(xcm.n3850714)=2.500252249870214
.nodeset v(xcm.n3850724)=2.499999000028001
.nodeset v(xcm.n4031911)=2.525008769649185
.nodeset v(xcm.n4243633)=2.094999361549383
.nodeset v(xcm.n4736080)=2.546540242865907
.nodeset v(xcm.n4745674)=3.213267283701017
.nodeset v(xcm.n4747399)=3.213267283701017
.nodeset v(xcm.n4749239)=3.213267283701016
.nodeset v(xcm.n4796554)=3.213267283701016
.nodeset v(xcm.n4796572)=3.213267283701026
.nodeset v(xcm.n4797748)=3.213214879870764
.nodeset v(xcm.n4797760)=2.689176577246762
.nodeset v(xcm.n4798545)=3.213199158721687
.nodeset v(xcm.n4800105)=3.213199158721686
.nodeset v(xcm.n4809008)=2.49999875004255
.nodeset v(xcm.n4817896)=2.500252278900462
.nodeset v(xcm.n47456861)=3.213267283701017
.nodeset v(xcm.n47492651)=3.213267283701016
.nodeset v(xcm.n47965841)=3.213267283701026
.nodeset v(xcm.n48001371)=3.213199158721686
.nodeset v(xcm.sw_ol_opax388)=2.499998749999496
.nodeset v(xcm.v11)=2.499998694889493
.nodeset v(xcm.v12)=2.4999986948895
.nodeset v(xcm.vcc_b)=4.999997499998896
.nodeset v(xcm.vcc_clp)=4.984888919130345
.nodeset v(xcm.vclp)=2.525003226268538
.nodeset v(xcm.vee_b)=2.499998848042786e-06
.nodeset v(xcm.vee_clp)=0.02308225095710882
.nodeset v(xcm.vimon)=2.524998957092127
.nodeset v(xcm.vout_s)=2.525000222243037
.nodeset v(xcm.vsense)=2.525008769649185
.nodeset v(xcm.x_u4.e1_int1)=-3.00202e-07
.nodeset v(xcm.x_u6.g1_int1)=1.420122498707599e-06
.nodeset v(xcm.x_u10.gvo+_int1)=0
.nodeset v(xcm.x_u10.gvo-_int1)=0
.nodeset v(xcm.x_u11.gvo+_int1)=0
.nodeset v(xcm.x_u11.gvo-_int1)=0
.nodeset v(xcm.x_u12.gvo+_int1)=0
.nodeset v(xcm.x_u12.gvo-_int1)=0
.nodeset v(xcm.x_u16.gsw+_int1)=0
.nodeset v(xcm.x_u18.g1_int1)=1.510857850153793e-05
.nodeset v(xcm.x_u18.g1_int2)=0.02500020709263051
.nodeset v(xcm.x_u19.g1_int1)=2.307974848079847e-05
.nodeset v(xcm.x_u19.g1_int2)=-0.02500020709263051
.nodeset v(xcm.x_u22.g1_int1)=0
.nodeset v(xcm.x_u23.g1_int1)=0
.nodeset v(xcm.x_u26.g1_int1)=2.500020709263065e-05
.nodeset v(xcm.x_u27.g1_int1)=0
.nodeset v(xcm.x_u30.g1_int1)=1.116210531122708e-13
.nodeset v(xcm.x_u31.g1_int1)=2.501003104615762e-08
.nodeset v(xcm.x_u32.g1_int1)=0.7125591055278164
.nodeset v(xcm.x_u35.g1_int1)=0
.nodeset v(xcm.x_u38.3)=0
.nodeset v(xcm.x_u38.5)=0
.nodeset v(xcm.x_u39.3)=0
.nodeset v(xcm.x_u39.5)=0
.nodeset v(xcm.x_u40.5)=0
.nodeset v(xex.cl_clamp)=2.249988180945172
.nodeset v(xex.clamp)=2.249932754668407
.nodeset v(xex.claw_clamp)=2.249988180945172
.nodeset v(xex.esdn)=2.249999938718351
.nodeset v(xex.esdp)=2.249999753991369
.nodeset v(xex.mid)=2.499998749999496
.nodeset v(xex.n2991553)=2.49999872499885
.nodeset v(xex.n2991555)=2.249999453789369
.nodeset v(xex.n2991563)=2.249999428617793
.nodeset v(xex.n2991573)=2.249999753991369
.nodeset v(xex.n2991579)=2.499998499872028
.nodeset v(xex.n2991581)=2.499999000056634
.nodeset v(xex.n2991583)=2.249999428617793
.nodeset v(xex.n2991587)=2.249999928802398
.nodeset v(xex.n2991619)=2.249999938718351
.nodeset v(xex.n2991623)=5.099997499998895
.nodeset v(xex.n2991635)=-0.09999750000115196
.nodeset v(xex.n2991643)=2.249999928802398
.nodeset v(xex.n2991657)=2.249999928802398
.nodeset v(xex.n2991667)=2.499997754473773
.nodeset v(xex.n2991729)=2.499998749999496
.nodeset v(xex.n2991741)=2.499998749999496
.nodeset v(xex.n2991763)=2.499998749999496
.nodeset v(xex.n2991765)=2.499998749999496
.nodeset v(xex.n2991807)=62.4999987499995
.nodeset v(xex.n2991809)=2.499998749999496
.nodeset v(xex.n2991811)=2.499998749999496
.nodeset v(xex.n2991831)=2.499998749999496
.nodeset v(xex.n2991837)=2.499998749999496
.nodeset v(xex.n2991849)=-57.5000012500005
.nodeset v(xex.n2991901)=152.4999987499995
.nodeset v(xex.n2991905)=2.499998749999496
.nodeset v(xex.n2991907)=2.499998749999496
.nodeset v(xex.n2991925)=2.499998749999496
.nodeset v(xex.n2991931)=2.499998749999496
.nodeset v(xex.n2991943)=-147.5000012500005
.nodeset v(xex.n2991969)=2.249932754721611
.nodeset v(xex.n2991997)=4.985064250152158
.nodeset v(xex.n2992001)=0.02344125007359915
.nodeset v(xex.n2992029)=0.02344125007359915
.nodeset v(xex.n2992033)=4.985064250152158
.nodeset v(xex.n2992093)=2.499998694889553
.nodeset v(xex.n2992099)=2.499998694889439
.nodeset v(xex.n2992105)=2.499998749999496
.nodeset v(xex.n2992151)=2.499998744891283
.nodeset v(xex.n2992163)=2.249999775022906
.nodeset v(xex.n2992235)=2.249999775022905
.nodeset v(xex.n2992267)=-52.75001176394488
.nodeset v(xex.n2992287)=57.24998812583512
.nodeset v(xex.n2992295)=-52.75001181905482
.nodeset v(xex.n2992299)=-52.75001176394488
.nodeset v(xex.n2992323)=57.24998812583512
.nodeset v(xex.n2992331)=57.24998818094518
.nodeset v(xex.n2992375)=2.499998749999496
.nodeset v(xex.n2992397)=4.999997497498896
.nodeset v(xex.n2992413)=2.502498844298777e-06
.nodeset v(xex.n3201092)=-0.2528709684194035
.nodeset v(xex.n3294524)=2.249988180945172
.nodeset v(xex.n3294618)=2.249988180945172
.nodeset v(xex.n3294626)=-0.2528708098016876
.nodeset v(xex.n3294630)=1.189108407895259
.nodeset v(xex.n3294682)=-0.249990064058693
.nodeset v(xex.n3294772)=2.499989952534915
.nodeset v(xex.n3294776)=2.499998724997977
.nodeset v(xex.n3827259)=-0.2523330259573647
.nodeset v(xex.n3828449)=2.497798644663
.nodeset v(xex.n3850714)=2.500252249870214
.nodeset v(xex.n3850724)=2.499999000028001
.nodeset v(xex.n4031911)=2.249932754721611
.nodeset v(xex.n4243633)=2.094999361549383
.nodeset v(xex.n4736080)=2.03464746685876
.nodeset v(xex.n4745674)=-0.2528709684194039
.nodeset v(xex.n4747399)=-0.2528709684194039
.nodeset v(xex.n4749239)=-0.2528709684194039
.nodeset v(xex.n4796554)=-0.2528709684194039
.nodeset v(xex.n4796572)=-0.2528709684194047
.nodeset v(xex.n4797748)=-0.2526687151155755
.nodeset v(xex.n4797760)=1.769864323176175
.nodeset v(xex.n4798545)=-0.2526080391244259
.nodeset v(xex.n4800105)=-0.2526080391244268
.nodeset v(xex.n4809008)=2.499989952842043
.nodeset v(xex.n4817896)=2.500252278900462
.nodeset v(xex.n47456861)=-0.2528709684194039
.nodeset v(xex.n47492651)=-0.2528709684194039
.nodeset v(xex.n47965841)=-0.2528709684194047
.nodeset v(xex.n48001371)=-0.2526080391244268
.nodeset v(xex.sw_ol_opax388)=2.499998749999496
.nodeset v(xex.v11)=2.499998694889553
.nodeset v(xex.v12)=2.499998694889439
.nodeset v(xex.vcc_b)=4.999997499998895
.nodeset v(xex.vcc_clp)=4.985064247667093
.nodeset v(xex.vclp)=2.249988180945181
.nodeset v(xex.vee_b)=2.499998848051276e-06
.nodeset v(xex.vee_clp)=0.02344125255015663
.nodeset v(xex.vimon)=2.499998744891284
.nodeset v(xex.vout_s)=2.249999775022906
.nodeset v(xex.vsense)=2.249932754721611
.nodeset v(xex.x_u4.e1_int1)=-3.00202e-07
.nodeset v(xex.x_u6.g1_int1)=-0.2499988211970989
.nodeset v(xex.x_u10.gvo+_int1)=0
.nodeset v(xex.x_u10.gvo-_int1)=0
.nodeset v(xex.x_u11.gvo+_int1)=0
.nodeset v(xex.x_u11.gvo-_int1)=0
.nodeset v(xex.x_u12.gvo+_int1)=0
.nodeset v(xex.x_u12.gvo-_int1)=0
.nodeset v(xex.x_u16.gsw+_int1)=0
.nodeset v(xex.x_u18.g1_int1)=1.493324996461797e-05
.nodeset v(xex.x_u18.g1_int2)=-5.108212519644439e-09
.nodeset v(xex.x_u19.g1_int1)=2.343875007419678e-05
.nodeset v(xex.x_u19.g1_int2)=5.108212519644439e-09
.nodeset v(xex.x_u22.g1_int1)=0
.nodeset v(xex.x_u23.g1_int1)=0
.nodeset v(xex.x_u26.g1_int1)=0
.nodeset v(xex.x_u27.g1_int1)=5.108212897814157e-12
.nodeset v(xex.x_u30.g1_int1)=-9.915953962883611e-13
.nodeset v(xex.x_u31.g1_int1)=-2.500661063775667e-07
.nodeset v(xex.x_u32.g1_int1)=-2.750131670620249
.nodeset v(xex.x_u35.g1_int1)=0
.nodeset v(xex.x_u38.3)=0
.nodeset v(xex.x_u38.5)=0
.nodeset v(xex.x_u39.3)=0
.nodeset v(xex.x_u39.5)=0
.nodeset v(xex.x_u40.5)=0
.nodeset v(xr0.cl_clamp)=2.500002600738664
.nodeset v(xr0.clamp)=2.500002601533197
.nodeset v(xr0.claw_clamp)=2.500002600738664
.nodeset v(xr0.esdn)=2.500001639889166
.nodeset v(xr0.esdp)=2.500000015098113
.nodeset v(xr0.mid)=2.499998749999496
.nodeset v(xr0.n2991553)=2.499998749999622
.nodeset v(xr0.n2991555)=2.499995345098113
.nodeset v(xr0.n2991563)=2.499995344908319
.nodeset v(xr0.n2991573)=2.500000015098113
.nodeset v(xr0.n2991579)=2.499995602981784
.nodeset v(xr0.n2991581)=2.500001897971614
.nodeset v(xr0.n2991583)=2.499995344908319
.nodeset v(xr0.n2991587)=2.500001639898148
.nodeset v(xr0.n2991619)=2.500001639889166
.nodeset v(xr0.n2991623)=5.099997499998895
.nodeset v(xr0.n2991635)=-0.09999750000115196
.nodeset v(xr0.n2991643)=2.500001639898148
.nodeset v(xr0.n2991657)=2.500001639898148
.nodeset v(xr0.n2991667)=2.499998750014829
.nodeset v(xr0.n2991729)=2.499998749999496
.nodeset v(xr0.n2991741)=2.499998749999496
.nodeset v(xr0.n2991763)=2.499998749999496
.nodeset v(xr0.n2991765)=2.499998749999496
.nodeset v(xr0.n2991807)=62.4999987499995
.nodeset v(xr0.n2991809)=2.499998749999496
.nodeset v(xr0.n2991811)=2.499998749999496
.nodeset v(xr0.n2991831)=2.499998749999496
.nodeset v(xr0.n2991837)=2.499998749999496
.nodeset v(xr0.n2991849)=-57.5000012500005
.nodeset v(xr0.n2991901)=152.4999987499995
.nodeset v(xr0.n2991905)=2.49999874999964
.nodeset v(xr0.n2991907)=2.49999874999964
.nodeset v(xr0.n2991925)=2.49999874999964
.nodeset v(xr0.n2991931)=2.49999874999964
.nodeset v(xr0.n2991943)=-147.5000012500005
.nodeset v(xr0.n2991969)=2.500002601592314
.nodeset v(xr0.n2991997)=4.985064242398068
.nodeset v(xr0.n2992001)=0.02344123381314487
.nodeset v(xr0.n2992029)=0.02344123381314487
.nodeset v(xr0.n2992033)=4.985064242398068
.nodeset v(xr0.n2992093)=2.499998694889491
.nodeset v(xr0.n2992099)=2.4999986948895
.nodeset v(xr0.n2992105)=2.499998749999496
.nodeset v(xr0.n2992151)=2.499999864372349
.nodeset v(xr0.n2992163)=2.500002600477872
.nodeset v(xr0.n2992235)=2.500002600477872
.nodeset v(xr0.n2992267)=-52.49999734415132
.nodeset v(xr0.n2992287)=57.50000254562867
.nodeset v(xr0.n2992295)=-52.49999739926133
.nodeset v(xr0.n2992299)=-52.49999734415132
.nodeset v(xr0.n2992323)=57.50000254562867
.nodeset v(xr0.n2992331)=57.50000260073867
.nodeset v(xr0.n2992375)=2.499998749999496
.nodeset v(xr0.n2992397)=4.999997497498896
.nodeset v(xr0.n2992413)=2.502498844298778e-06
.nodeset v(xr0.n3201092)=2.500060671661987
.nodeset v(xr0.n3294524)=2.500002600738622
.nodeset v(xr0.n3294618)=2.500002600738664
.nodeset v(xr0.n3294626)=2.500060671658421
.nodeset v(xr0.n3294630)=2.500028236505444
.nodeset v(xr0.n3294682)=2.500060606759234
.nodeset v(xr0.n3294772)=2.499998750044015
.nodeset v(xr0.n3294776)=2.499998749999622
.nodeset v(xr0.n3827259)=2.500060659561789
.nodeset v(xr0.n3828449)=2.499998799487555
.nodeset v(xr0.n3850714)=2.501037249469892
.nodeset v(xr0.n3850724)=2.500001897469577
.nodeset v(xr0.n4031911)=2.500002601592314
.nodeset v(xr0.n4243633)=1.186000734139104
.nodeset v(xr0.n4736080)=2.500005917482056
.nodeset v(xr0.n4745674)=2.500060671661987
.nodeset v(xr0.n4747399)=2.500060671661987
.nodeset v(xr0.n4749239)=2.500060671661986
.nodeset v(xr0.n4796554)=2.500060671661986
.nodeset v(xr0.n4796572)=2.500060671661995
.nodeset v(xr0.n4797748)=2.500060667112611
.nodeset v(xr0.n4797760)=2.500015173274907
.nodeset v(xr0.n4798545)=2.500060665747796
.nodeset v(xr0.n4800105)=2.500060665747796
.nodeset v(xr0.n4809008)=2.499998750044028
.nodeset v(xr0.n4817896)=2.501037415115775
.nodeset v(xr0.n47456861)=2.500060671661987
.nodeset v(xr0.n47492651)=2.500060671661986
.nodeset v(xr0.n47965841)=2.500060671661995
.nodeset v(xr0.n48001371)=2.500060665747796
.nodeset v(xr0.sw_ol_opa4388)=2.499998749999496
.nodeset v(xr0.v11)=2.499998694889491
.nodeset v(xr0.v12)=2.4999986948895
.nodeset v(xr0.vcc_b)=4.999997499998895
.nodeset v(xr0.vcc_clp)=4.985064239913003
.nodeset v(xr0.vclp)=2.500002600738668
.nodeset v(xr0.vee_b)=2.499998848051277e-06
.nodeset v(xr0.vee_clp)=0.02344123628970237
.nodeset v(xr0.vimon)=2.499999864372349
.nodeset v(xr0.vout_s)=2.500002600477872
.nodeset v(xr0.vsense)=2.500002601592314
.nodeset v(xr0.x_u4.e1_int1)=-4.669999999999999e-06
.nodeset v(xr0.x_u6.g1_int1)=2.889898652824741e-06
.nodeset v(xr0.x_u10.gvo+_int1)=0
.nodeset v(xr0.x_u10.gvo-_int1)=0
.nodeset v(xr0.x_u11.gvo+_int1)=0
.nodeset v(xr0.x_u11.gvo-_int1)=0
.nodeset v(xr0.x_u12.gvo+_int1)=0
.nodeset v(xr0.x_u12.gvo-_int1)=0
.nodeset v(xr0.x_u16.gsw+_int1)=0
.nodeset v(xr0.x_u18.g1_int1)=1.493325771870787e-05
.nodeset v(xr0.x_u18.g1_int2)=1.114372853106005e-06
.nodeset v(xr0.x_u19.g1_int1)=2.34387338137425e-05
.nodeset v(xr0.x_u19.g1_int2)=-1.114372853106005e-06
.nodeset v(xr0.x_u22.g1_int1)=0
.nodeset v(xr0.x_u23.g1_int1)=0
.nodeset v(xr0.x_u26.g1_int1)=1.114372853109474e-09
.nodeset v(xr0.x_u27.g1_int1)=0
.nodeset v(xr0.x_u30.g1_int1)=8.982072897956161e-16
.nodeset v(xr0.x_u31.g1_int1)=3.851585717029593e-12
.nodeset v(xr0.x_u32.g1_int1)=6.186007476571831e-05
.nodeset v(xr0.x_u35.g1_int1)=0
.nodeset v(xr0.x_u38.3)=0
.nodeset v(xr0.x_u38.5)=0
.nodeset v(xr0.x_u39.3)=0
.nodeset v(xr0.x_u39.5)=0
.nodeset v(xr0.x_u40.5)=0
.nodeset v(xr1.cl_clamp)=0.9998395648310695
.nodeset v(xr1.clamp)=0.9995069862343371
.nodeset v(xr1.claw_clamp)=0.9998395648310695
.nodeset v(xr1.esdn)=2.250001438509968
.nodeset v(xr1.esdp)=2.24999977898766
.nodeset v(xr1.mid)=2.499998749999496
.nodeset v(xr1.n2991553)=2.499998724998851
.nodeset v(xr1.n2991555)=2.24999510898766
.nodeset v(xr1.n2991563)=2.249995083816088
.nodeset v(xr1.n2991573)=2.24999977898766
.nodeset v(xr1.n2991579)=2.499995602981785
.nodeset v(xr1.n2991581)=2.500001897971615
.nodeset v(xr1.n2991583)=2.249995083816087
.nodeset v(xr1.n2991587)=2.250001378805917
.nodeset v(xr1.n2991619)=2.250001438509968
.nodeset v(xr1.n2991623)=5.099997499998895
.nodeset v(xr1.n2991635)=-0.09999750000115129
.nodeset v(xr1.n2991643)=2.250001378806048
.nodeset v(xr1.n2991657)=2.250001378806047
.nodeset v(xr1.n2991667)=2.499992776463806
.nodeset v(xr1.n2991729)=2.499998749999496
.nodeset v(xr1.n2991741)=2.499998749999496
.nodeset v(xr1.n2991763)=2.499998749999496
.nodeset v(xr1.n2991765)=2.499998749999496
.nodeset v(xr1.n2991807)=62.4999987499995
.nodeset v(xr1.n2991809)=2.499998749999496
.nodeset v(xr1.n2991811)=2.499998749999496
.nodeset v(xr1.n2991831)=2.499998749999496
.nodeset v(xr1.n2991837)=2.499998749999496
.nodeset v(xr1.n2991849)=-57.5000012500005
.nodeset v(xr1.n2991901)=152.4999987499995
.nodeset v(xr1.n2991905)=2.499998749999496
.nodeset v(xr1.n2991907)=2.499998749999496
.nodeset v(xr1.n2991925)=2.499998749999496
.nodeset v(xr1.n2991931)=2.499998749999496
.nodeset v(xr1.n2991943)=-147.5000012500005
.nodeset v(xr1.n2991969)=0.9995069862579723
.nodeset v(xr1.n2991997)=4.988527500116859
.nodeset v(xr1.n2992001)=0.05176499793664192
.nodeset v(xr1.n2992029)=0.05176499793664192
.nodeset v(xr1.n2992033)=4.988527500116859
.nodeset v(xr1.n2992093)=2.499998694889829
.nodeset v(xr1.n2992099)=2.499998694889163
.nodeset v(xr1.n2992105)=2.499998749999496
.nodeset v(xr1.n2992151)=1.249998821029819
.nodeset v(xr1.n2992163)=1.000001355926879
.nodeset v(xr1.n2992235)=1.000001355926879
.nodeset v(xr1.n2992267)=-54.00016038005926
.nodeset v(xr1.n2992287)=55.99983950972074
.nodeset v(xr1.n2992295)=-54.00016043516892
.nodeset v(xr1.n2992299)=-54.00016038005926
.nodeset v(xr1.n2992323)=55.99983950972074
.nodeset v(xr1.n2992331)=55.99983956483108
.nodeset v(xr1.n2992375)=2.499998749999496
.nodeset v(xr1.n2992397)=4.999997497498896
.nodeset v(xr1.n2992413)=2.502498844968547e-06
.nodeset v(xr1.n3201092)=-35.91528693430359
.nodeset v(xr1.n3294524)=0.9998395648313063
.nodeset v(xr1.n3294618)=0.9998395648310695
.nodeset v(xr1.n3294626)=-35.91528472085164
.nodeset v(xr1.n3294630)=-15.79299443300198
.nodeset v(xr1.n3294682)=-35.87497134176965
.nodeset v(xr1.n3294772)=2.499989952535794
.nodeset v(xr1.n3294776)=2.499998724997979
.nodeset v(xr1.n3827259)=-35.90778014485318
.nodeset v(xr1.n3828449)=2.469297088213043
.nodeset v(xr1.n3850714)=2.501037249469892
.nodeset v(xr1.n3850724)=2.500001897469577
.nodeset v(xr1.n4031911)=0.9995069862579723
.nodeset v(xr1.n4243633)=1.186000734139105
.nodeset v(xr1.n4736080)=-0.2922872096460318
.nodeset v(xr1.n4745674)=-35.91528693430359
.nodeset v(xr1.n4747399)=-35.91528693430359
.nodeset v(xr1.n4749239)=-35.91528693430362
.nodeset v(xr1.n4796554)=-35.91528693430362
.nodeset v(xr1.n4796572)=-35.91528693430373
.nodeset v(xr1.n4797748)=-35.91246456374431
.nodeset v(xr1.n4797760)=-7.688758969516678
.nodeset v(xr1.n4798545)=-35.91161785257648
.nodeset v(xr1.n4800105)=-35.91161785257649
.nodeset v(xr1.n4809008)=2.499989952842839
.nodeset v(xr1.n4817896)=2.501037415115775
.nodeset v(xr1.n47456861)=-35.91528693430359
.nodeset v(xr1.n47492651)=-35.91528693430362
.nodeset v(xr1.n47965841)=-35.91528693430373
.nodeset v(xr1.n48001371)=-35.91161785257649
.nodeset v(xr1.sw_ol_opa4388)=2.499998749999496
.nodeset v(xr1.v11)=2.499998694889829
.nodeset v(xr1.v12)=2.499998694889163
.nodeset v(xr1.vcc_b)=4.999997499998895
.nodeset v(xr1.vcc_clp)=4.98852749762833
.nodeset v(xr1.vclp)=0.9998395648310776
.nodeset v(xr1.vee_b)=2.499998848721046e-06
.nodeset v(xr1.vee_clp)=0.05176500038487566
.nodeset v(xr1.vimon)=1.249998821029819
.nodeset v(xr1.vout_s)=1.000001355926879
.nodeset v(xr1.vsense)=0.9995069862579723
.nodeset v(xr1.x_u4.e1_int1)=-4.669999999999999e-06
.nodeset v(xr1.x_u6.g1_int1)=-0.249997371193579
.nodeset v(xr1.x_u10.gvo+_int1)=0
.nodeset v(xr1.x_u10.gvo-_int1)=0
.nodeset v(xr1.x_u11.gvo+_int1)=0
.nodeset v(xr1.x_u11.gvo-_int1)=0
.nodeset v(xr1.x_u12.gvo+_int1)=0
.nodeset v(xr1.x_u12.gvo-_int1)=0
.nodeset v(xr1.x_u16.gsw+_int1)=0
.nodeset v(xr1.x_u18.g1_int1)=1.147e-05
.nodeset v(xr1.x_u18.g1_int2)=-1.249999928969677
.nodeset v(xr1.x_u19.g1_int1)=5.176249793656912e-05
.nodeset v(xr1.x_u19.g1_int2)=1.249999928969677
.nodeset v(xr1.x_u22.g1_int1)=0
.nodeset v(xr1.x_u23.g1_int1)=0
.nodeset v(xr1.x_u26.g1_int1)=0
.nodeset v(xr1.x_u27.g1_int1)=0.001249999928969678
.nodeset v(xr1.x_u30.g1_int1)=-5.970392040997863e-12
.nodeset v(xr1.x_u31.g1_int1)=-1.500492429862277e-06
.nodeset v(xr1.x_u32.g1_int1)=-38.3770772330663
.nodeset v(xr1.x_u35.g1_int1)=0
.nodeset v(xr1.x_u38.3)=0
.nodeset v(xr1.x_u38.5)=0
.nodeset v(xr1.x_u39.3)=0
.nodeset v(xr1.x_u39.5)=0
.nodeset v(xr1.x_u40.5)=0
.nodeset v(xr2.cl_clamp)=2.500002600505884
.nodeset v(xr2.clamp)=2.500002601300366
.nodeset v(xr2.claw_clamp)=2.500002600505884
.nodeset v(xr2.esdn)=2.500001639860378
.nodeset v(xr2.esdp)=2.500000015098119
.nodeset v(xr2.mid)=2.499998749999496
.nodeset v(xr2.n2991553)=2.499998749999623
.nodeset v(xr2.n2991555)=2.499995345098119
.nodeset v(xr2.n2991563)=2.499995344908324
.nodeset v(xr2.n2991573)=2.500000015098119
.nodeset v(xr2.n2991579)=2.499995602981785
.nodeset v(xr2.n2991581)=2.500001897971615
.nodeset v(xr2.n2991583)=2.499995344908324
.nodeset v(xr2.n2991587)=2.500001639898154
.nodeset v(xr2.n2991619)=2.500001639860378
.nodeset v(xr2.n2991623)=5.099997499998896
.nodeset v(xr2.n2991635)=-0.09999750000115196
.nodeset v(xr2.n2991643)=2.500001639898298
.nodeset v(xr2.n2991657)=2.500001639898298
.nodeset v(xr2.n2991667)=2.49999875001483
.nodeset v(xr2.n2991729)=2.499998749999496
.nodeset v(xr2.n2991741)=2.499998749999496
.nodeset v(xr2.n2991763)=2.499998749999496
.nodeset v(xr2.n2991765)=2.499998749999496
.nodeset v(xr2.n2991807)=62.4999987499995
.nodeset v(xr2.n2991809)=2.499998749999496
.nodeset v(xr2.n2991811)=2.499998749999496
.nodeset v(xr2.n2991831)=2.499998749999496
.nodeset v(xr2.n2991837)=2.499998749999496
.nodeset v(xr2.n2991849)=-57.5000012500005
.nodeset v(xr2.n2991901)=152.4999987499995
.nodeset v(xr2.n2991905)=2.499998749999496
.nodeset v(xr2.n2991907)=2.499998749999496
.nodeset v(xr2.n2991925)=2.499998749999496
.nodeset v(xr2.n2991931)=2.499998749999496
.nodeset v(xr2.n2991943)=-147.5000012500005
.nodeset v(xr2.n2991969)=2.500002601359483
.nodeset v(xr2.n2991997)=4.985064242399482
.nodeset v(xr2.n2992001)=0.02344123381610743
.nodeset v(xr2.n2992029)=0.02344123381610743
.nodeset v(xr2.n2992033)=4.985064242399482
.nodeset v(xr2.n2992093)=2.499998694889494
.nodeset v(xr2.n2992099)=2.499998694889499
.nodeset v(xr2.n2992105)=2.499998749999496
.nodeset v(xr2.n2992151)=2.499999864168386
.nodeset v(xr2.n2992163)=2.500002600245118
.nodeset v(xr2.n2992235)=2.500002600245119
.nodeset v(xr2.n2992267)=-52.49999734438411
.nodeset v(xr2.n2992287)=57.50000254539589
.nodeset v(xr2.n2992295)=-52.49999739949411
.nodeset v(xr2.n2992299)=-52.49999734438411
.nodeset v(xr2.n2992323)=57.50000254539589
.nodeset v(xr2.n2992331)=57.50000260050589
.nodeset v(xr2.n2992375)=2.499998749999496
.nodeset v(xr2.n2992397)=4.999997497498897
.nodeset v(xr2.n2992413)=2.502498844298777e-06
.nodeset v(xr2.n3201092)=2.500060665608392
.nodeset v(xr2.n3294524)=2.500002600505843
.nodeset v(xr2.n3294618)=2.500002600505884
.nodeset v(xr2.n3294626)=2.500060665604825
.nodeset v(xr2.n3294630)=2.50002823362278
.nodeset v(xr2.n3294682)=2.500060600712459
.nodeset v(xr2.n3294772)=2.499998750044016
.nodeset v(xr2.n3294776)=2.499998749999623
.nodeset v(xr2.n3827259)=2.500060653509379
.nodeset v(xr2.n3828449)=2.499998799482718
.nodeset v(xr2.n3850714)=2.501037249469893
.nodeset v(xr2.n3850724)=2.500001897469577
.nodeset v(xr2.n4031911)=2.500002601359483
.nodeset v(xr2.n4243633)=1.186000734139104
.nodeset v(xr2.n4736080)=2.500005917048778
.nodeset v(xr2.n4745674)=2.500060665608392
.nodeset v(xr2.n4747399)=2.500060665608391
.nodeset v(xr2.n4749239)=2.500060665608394
.nodeset v(xr2.n4796554)=2.500060665608394
.nodeset v(xr2.n4796572)=2.500060665608402
.nodeset v(xr2.n4797748)=2.500060661059463
.nodeset v(xr2.n4797760)=2.500015171669333
.nodeset v(xr2.n4798545)=2.500060659694783
.nodeset v(xr2.n4800105)=2.500060659694782
.nodeset v(xr2.n4809008)=2.499998750044142
.nodeset v(xr2.n4817896)=2.501037415115775
.nodeset v(xr2.n47456861)=2.500060665608392
.nodeset v(xr2.n47492651)=2.500060665608394
.nodeset v(xr2.n47965841)=2.500060665608402
.nodeset v(xr2.n48001371)=2.500060659694782
.nodeset v(xr2.sw_ol_opa4388)=2.499998749999496
.nodeset v(xr2.v11)=2.499998694889494
.nodeset v(xr2.v12)=2.499998694889499
.nodeset v(xr2.vcc_b)=4.999997499998896
.nodeset v(xr2.vcc_clp)=4.985064239914417
.nodeset v(xr2.vclp)=2.500002600505894
.nodeset v(xr2.vee_b)=2.499998848051276e-06
.nodeset v(xr2.vee_clp)=0.02344123629266494
.nodeset v(xr2.vimon)=2.499999864168386
.nodeset v(xr2.vout_s)=2.500002600245118
.nodeset v(xr2.vsense)=2.500002601359483
.nodeset v(xr2.x_u4.e1_int1)=-4.669999999999999e-06
.nodeset v(xr2.x_u6.g1_int1)=2.889898657265633e-06
.nodeset v(xr2.x_u10.gvo+_int1)=0
.nodeset v(xr2.x_u10.gvo-_int1)=0
.nodeset v(xr2.x_u11.gvo+_int1)=0
.nodeset v(xr2.x_u11.gvo-_int1)=0
.nodeset v(xr2.x_u12.gvo+_int1)=0
.nodeset v(xr2.x_u12.gvo-_int1)=0
.nodeset v(xr2.x_u16.gsw+_int1)=0
.nodeset v(xr2.x_u18.g1_int1)=1.493325771729511e-05
.nodeset v(xr2.x_u18.g1_int2)=1.114168889593259e-06
.nodeset v(xr2.x_u19.g1_int1)=2.343873381670507e-05
.nodeset v(xr2.x_u19.g1_int2)=-1.114168889593259e-06
.nodeset v(xr2.x_u22.g1_int1)=0
.nodeset v(xr2.x_u23.g1_int1)=0
.nodeset v(xr2.x_u26.g1_int1)=1.114168889527339e-09
.nodeset v(xr2.x_u27.g1_int1)=0
.nodeset v(xr2.x_u30.g1_int1)=3.792051308376676e-15
.nodeset v(xr2.x_u31.g1_int1)=3.851696739332056e-12
.nodeset v(xr2.x_u32.g1_int1)=6.185402753544622e-05
.nodeset v(xr2.x_u35.g1_int1)=0
.nodeset v(xr2.x_u38.3)=0
.nodeset v(xr2.x_u38.5)=0
.nodeset v(xr2.x_u39.3)=0
.nodeset v(xr2.x_u39.5)=0
.nodeset v(xr2.x_u40.5)=0
.nodeset v(xr3.cl_clamp)=2.50000260222351
.nodeset v(xr3.clamp)=2.500002603163011
.nodeset v(xr3.claw_clamp)=2.50000260222351
.nodeset v(xr3.esdn)=2.500001640136223
.nodeset v(xr3.esdp)=2.500000015099361
.nodeset v(xr3.mid)=2.499998749999496
.nodeset v(xr3.n2991553)=2.499998749999622
.nodeset v(xr3.n2991555)=2.499995345099361
.nodeset v(xr3.n2991563)=2.499995345158605
.nodeset v(xr3.n2991573)=2.500000015099361
.nodeset v(xr3.n2991579)=2.499995602981784
.nodeset v(xr3.n2991581)=2.500001897971614
.nodeset v(xr3.n2991583)=2.499995345158605
.nodeset v(xr3.n2991587)=2.500001640148435
.nodeset v(xr3.n2991619)=2.500001640136223
.nodeset v(xr3.n2991623)=5.099997499998896
.nodeset v(xr3.n2991635)=-0.09999750000115196
.nodeset v(xr3.n2991643)=2.500001640148579
.nodeset v(xr3.n2991657)=2.500001640148579
.nodeset v(xr3.n2991667)=2.499998750014836
.nodeset v(xr3.n2991729)=2.49999874999964
.nodeset v(xr3.n2991741)=2.49999874999964
.nodeset v(xr3.n2991763)=2.499998749999496
.nodeset v(xr3.n2991765)=2.499998749999496
.nodeset v(xr3.n2991807)=62.4999987499995
.nodeset v(xr3.n2991809)=2.499998749999496
.nodeset v(xr3.n2991811)=2.499998749999496
.nodeset v(xr3.n2991831)=2.499998749999496
.nodeset v(xr3.n2991837)=2.499998749999496
.nodeset v(xr3.n2991849)=-57.5000012500005
.nodeset v(xr3.n2991901)=152.4999987499995
.nodeset v(xr3.n2991905)=2.49999874999964
.nodeset v(xr3.n2991907)=2.49999874999964
.nodeset v(xr3.n2991925)=2.49999874999964
.nodeset v(xr3.n2991931)=2.49999874999964
.nodeset v(xr3.n2991943)=-147.5000012500005
.nodeset v(xr3.n2991969)=2.500002603222129
.nodeset v(xr3.n2991997)=4.985064242389497
.nodeset v(xr3.n2992001)=0.02344123379516849
.nodeset v(xr3.n2992029)=0.02344123379516849
.nodeset v(xr3.n2992033)=4.985064242389497
.nodeset v(xr3.n2992093)=2.499998694889495
.nodeset v(xr3.n2992099)=2.499998694889496
.nodeset v(xr3.n2992105)=2.499998749999496
.nodeset v(xr3.n2992151)=2.499999865609967
.nodeset v(xr3.n2992163)=2.500002601962559
.nodeset v(xr3.n2992235)=2.500002601962558
.nodeset v(xr3.n2992267)=-52.49999734266648
.nodeset v(xr3.n2992287)=57.50000254711352
.nodeset v(xr3.n2992295)=-52.49999739777648
.nodeset v(xr3.n2992299)=-52.49999734266648
.nodeset v(xr3.n2992323)=57.50000254711352
.nodeset v(xr3.n2992331)=57.50000260222352
.nodeset v(xr3.n2992375)=2.499998749999496
.nodeset v(xr3.n2992397)=4.999997497498897
.nodeset v(xr3.n2992413)=2.502498844298776e-06
.nodeset v(xr3.n3201092)=2.500060709729799
.nodeset v(xr3.n3294524)=2.500002602368076
.nodeset v(xr3.n3294618)=2.50000260222351
.nodeset v(xr3.n3294626)=2.500060709726231
.nodeset v(xr3.n3294630)=2.500028254632974
.nodeset v(xr3.n3294682)=2.500060644786572
.nodeset v(xr3.n3294772)=2.499998750044015
.nodeset v(xr3.n3294776)=2.499998749999622
.nodeset v(xr3.n3827259)=2.500060697622166
.nodeset v(xr3.n3828449)=2.499998799517979
.nodeset v(xr3.n3850714)=2.501037249469892
.nodeset v(xr3.n3850724)=2.500001897469577
.nodeset v(xr3.n4031911)=2.500002603222129
.nodeset v(xr3.n4243633)=1.186000734139104
.nodeset v(xr3.n4736080)=2.500005920515001
.nodeset v(xr3.n4745674)=2.500060709729799
.nodeset v(xr3.n4747399)=2.500060709729798
.nodeset v(xr3.n4749239)=2.500060709729799
.nodeset v(xr3.n4796554)=2.500060709729799
.nodeset v(xr3.n4796572)=2.500060709729809
.nodeset v(xr3.n4797748)=2.500060705177628
.nodeset v(xr3.n4797760)=2.500015183371506
.nodeset v(xr3.n4798545)=2.500060703811975
.nodeset v(xr3.n4800105)=2.500060703811976
.nodeset v(xr3.n4809008)=2.499998750044028
.nodeset v(xr3.n4817896)=2.501037415115775
.nodeset v(xr3.n47456861)=2.500060709729799
.nodeset v(xr3.n47492651)=2.500060709729799
.nodeset v(xr3.n47965841)=2.500060709729809
.nodeset v(xr3.n48001371)=2.500060703811976
.nodeset v(xr3.sw_ol_opa4388)=2.499998749999496
.nodeset v(xr3.v11)=2.499998694889495
.nodeset v(xr3.v12)=2.499998694889496
.nodeset v(xr3.vcc_b)=4.999997499998896
.nodeset v(xr3.vcc_clp)=4.985064239904432
.nodeset v(xr3.vclp)=2.500002602223518
.nodeset v(xr3.vee_b)=2.499998848051275e-06
.nodeset v(xr3.vee_clp)=0.02344123627172599
.nodeset v(xr3.vimon)=2.499999865609967
.nodeset v(xr3.vout_s)=2.500002601962559
.nodeset v(xr3.vsense)=2.500002603222129
.nodeset v(xr3.x_u4.e1_int1)=-4.669999999999999e-06
.nodeset v(xr3.x_u6.g1_int1)=2.890148939282966e-06
.nodeset v(xr3.x_u10.gvo+_int1)=0
.nodeset v(xr3.x_u10.gvo-_int1)=0
.nodeset v(xr3.x_u11.gvo+_int1)=0
.nodeset v(xr3.x_u11.gvo-_int1)=0
.nodeset v(xr3.x_u12.gvo+_int1)=0
.nodeset v(xr3.x_u12.gvo-_int1)=0
.nodeset v(xr3.x_u16.gsw+_int1)=0
.nodeset v(xr3.x_u18.g1_int1)=1.493325772728024e-05
.nodeset v(xr3.x_u18.g1_int2)=1.115610471114081e-06
.nodeset v(xr3.x_u19.g1_int1)=2.343873379576612e-05
.nodeset v(xr3.x_u19.g1_int2)=-1.115610471114081e-06
.nodeset v(xr3.x_u22.g1_int1)=0
.nodeset v(xr3.x_u23.g1_int1)=0
.nodeset v(xr3.x_u26.g1_int1)=1.115610471190409e-09
.nodeset v(xr3.x_u27.g1_int1)=0
.nodeset v(xr3.x_u30.g1_int1)=1.235611005873105e-15
.nodeset v(xr3.x_u31.g1_int1)=3.853251051566531e-12
.nodeset v(xr3.x_u32.g1_int1)=6.189810437717824e-05
.nodeset v(xr3.x_u35.g1_int1)=1.443289932012704e-13
.nodeset v(xr3.x_u38.3)=0
.nodeset v(xr3.x_u38.5)=0
.nodeset v(xr3.x_u39.3)=0
.nodeset v(xr3.x_u39.5)=0
.nodeset v(xr3.x_u40.5)=0
.nodeset v(xt0.cl_clamp)=4.376040083299976
.nodeset v(xt0.clamp)=4.376455993158743
.nodeset v(xt0.claw_clamp)=4.376040083299976
.nodeset v(xt0.esdn)=2.500001565345508
.nodeset v(xt0.esdp)=2.500000015250105
.nodeset v(xt0.mid)=2.499998749999496
.nodeset v(xt0.n2991553)=2.499998749999622
.nodeset v(xt0.n2991555)=2.499995345250105
.nodeset v(xt0.n2991563)=2.499995345060311
.nodeset v(xt0.n2991573)=2.500000015250105
.nodeset v(xt0.n2991579)=2.499995602981784
.nodeset v(xt0.n2991581)=2.500001897971614
.nodeset v(xt0.n2991583)=2.499995345060311
.nodeset v(xt0.n2991587)=2.500001640050141
.nodeset v(xt0.n2991619)=2.500001565345508
.nodeset v(xt0.n2991623)=5.099997499998896
.nodeset v(xt0.n2991635)=-0.09999750000115205
.nodeset v(xt0.n2991643)=2.500001640050141
.nodeset v(xt0.n2991657)=2.500001640050141
.nodeset v(xt0.n2991667)=2.500006220273299
.nodeset v(xt0.n2991729)=2.499998749999496
.nodeset v(xt0.n2991741)=2.499998749999496
.nodeset v(xt0.n2991763)=2.499998749999496
.nodeset v(xt0.n2991765)=2.499998749999496
.nodeset v(xt0.n2991807)=62.4999987499995
.nodeset v(xt0.n2991809)=2.49999874999964
.nodeset v(xt0.n2991811)=2.49999874999964
.nodeset v(xt0.n2991831)=2.49999874999964
.nodeset v(xt0.n2991837)=2.49999874999964
.nodeset v(xt0.n2991849)=-57.5000012500005
.nodeset v(xt0.n2991901)=152.4999987499995
.nodeset v(xt0.n2991905)=2.49999874999964
.nodeset v(xt0.n2991907)=2.49999874999964
.nodeset v(xt0.n2991925)=2.49999874999964
.nodeset v(xt0.n2991931)=2.49999874999964
.nodeset v(xt0.n2991943)=-147.5000012500005
.nodeset v(xt0.n2991969)=4.376455993262232
.nodeset v(xt0.n2991997)=4.982524561913031
.nodeset v(xt0.n2992001)=0.01950485140248162
.nodeset v(xt0.n2992029)=0.01950485140248162
.nodeset v(xt0.n2992033)=4.982524561913031
.nodeset v(xt0.n2992093)=2.499998694889082
.nodeset v(xt0.n2992099)=2.499998694889908
.nodeset v(xt0.n2992105)=2.499998749999496
.nodeset v(xt0.n2992151)=2.816556805976619
.nodeset v(xt0.n2992163)=4.375929728161479
.nodeset v(xt0.n2992235)=4.37592972816148
.nodeset v(xt0.n2992267)=-50.6239598615896
.nodeset v(xt0.n2992287)=59.3760400281904
.nodeset v(xt0.n2992295)=-50.62395991670002
.nodeset v(xt0.n2992299)=-50.6239598615896
.nodeset v(xt0.n2992323)=59.3760400281904
.nodeset v(xt0.n2992331)=59.37604008329998
.nodeset v(xt0.n2992375)=2.499998749999496
.nodeset v(xt0.n2992397)=4.999997497498897
.nodeset v(xt0.n2992413)=2.502498844205692e-06
.nodeset v(xt0.n3201092)=28.70245538609112
.nodeset v(xt0.n3294524)=4.376040083299934
.nodeset v(xt0.n3294618)=4.376040083299976
.nodeset v(xt0.n3294626)=28.70245387633068
.nodeset v(xt0.n3294630)=14.97735905290027
.nodeset v(xt0.n3294682)=28.67500548933413
.nodeset v(xt0.n3294772)=2.49999875004402
.nodeset v(xt0.n3294776)=2.499998749999622
.nodeset v(xt0.n3827259)=28.69733512415512
.nodeset v(xt0.n3828449)=2.520939866205855
.nodeset v(xt0.n3850714)=2.501037249469892
.nodeset v(xt0.n3850724)=2.500001897469577
.nodeset v(xt0.n4031911)=4.376455993262232
.nodeset v(xt0.n4243633)=1.186000734139104
.nodeset v(xt0.n4736080)=5.991924091310647
.nodeset v(xt0.n4745674)=28.70245538609112
.nodeset v(xt0.n4747399)=28.70245538609111
.nodeset v(xt0.n4749239)=28.70245538609112
.nodeset v(xt0.n4796554)=28.70245538609112
.nodeset v(xt0.n4796572)=28.70245538609123
.nodeset v(xt0.n4797748)=28.70053029192944
.nodeset v(xt0.n4797760)=9.44958867405292
.nodeset v(xt0.n4798545)=28.69995276368091
.nodeset v(xt0.n4800105)=28.69995276368092
.nodeset v(xt0.n4809008)=2.499998750044028
.nodeset v(xt0.n4817896)=2.501037415115775
.nodeset v(xt0.n47456861)=28.70245538609112
.nodeset v(xt0.n47492651)=28.70245538609112
.nodeset v(xt0.n47965841)=28.70245538609123
.nodeset v(xt0.n48001371)=28.69995276368092
.nodeset v(xt0.sw_ol_opa4388)=2.499998749999496
.nodeset v(xt0.v11)=2.499998694889082
.nodeset v(xt0.v12)=2.499998694889908
.nodeset v(xt0.vcc_b)=4.999997499998896
.nodeset v(xt0.vcc_clp)=4.982524559430504
.nodeset v(xt0.vclp)=4.376040083299984
.nodeset v(xt0.vee_b)=2.499998847958191e-06
.nodeset v(xt0.vee_clp)=0.01950485388297551
.nodeset v(xt0.vimon)=2.816556805976619
.nodeset v(xt0.vout_s)=4.375929728161479
.nodeset v(xt0.vsense)=4.376455993262232
.nodeset v(xt0.x_u4.e1_int1)=-4.669999999999999e-06
.nodeset v(xt0.x_u6.g1_int1)=2.890050645021347e-06
.nodeset v(xt0.x_u10.gvo+_int1)=0
.nodeset v(xt0.x_u10.gvo-_int1)=0
.nodeset v(xt0.x_u11.gvo+_int1)=0
.nodeset v(xt0.x_u11.gvo-_int1)=0
.nodeset v(xt0.x_u12.gvo+_int1)=0
.nodeset v(xt0.x_u12.gvo-_int1)=0
.nodeset v(xt0.x_u16.gsw+_int1)=0
.nodeset v(xt0.x_u18.g1_int1)=1.747293820368655e-05
.nodeset v(xt0.x_u18.g1_int2)=0.3165580559771231
.nodeset v(xt0.x_u19.g1_int1)=1.950235140317243e-05
.nodeset v(xt0.x_u19.g1_int2)=-0.3165580559771231
.nodeset v(xt0.x_u22.g1_int1)=0
.nodeset v(xt0.x_u23.g1_int1)=0
.nodeset v(xt0.x_u26.g1_int1)=0.0003165580559771229
.nodeset v(xt0.x_u27.g1_int1)=0
.nodeset v(xt0.x_u30.g1_int1)=7.470463267086891e-12
.nodeset v(xt0.x_u31.g1_int1)=1.87645807669945e-06
.nodeset v(xt0.x_u32.g1_int1)=26.17639525794948
.nodeset v(xt0.x_u35.g1_int1)=0
.nodeset v(xt0.x_u38.3)=0
.nodeset v(xt0.x_u38.5)=0
.nodeset v(xt0.x_u39.3)=0
.nodeset v(xt0.x_u39.5)=0
.nodeset v(xt0.x_u40.5)=0
.nodeset v(xt1.cl_clamp)=4.376040083211525
.nodeset v(xt1.clamp)=4.376455992925912
.nodeset v(xt1.claw_clamp)=4.376040083211525
.nodeset v(xt1.esdn)=2.500001565345508
.nodeset v(xt1.esdp)=2.500000015250105
.nodeset v(xt1.mid)=2.499998749999496
.nodeset v(xt1.n2991553)=2.499998749999622
.nodeset v(xt1.n2991555)=2.499995345250105
.nodeset v(xt1.n2991563)=2.499995345060311
.nodeset v(xt1.n2991573)=2.500000015250105
.nodeset v(xt1.n2991579)=2.499995602981784
.nodeset v(xt1.n2991581)=2.500001897971614
.nodeset v(xt1.n2991583)=2.499995345060311
.nodeset v(xt1.n2991587)=2.500001640050141
.nodeset v(xt1.n2991619)=2.500001565345508
.nodeset v(xt1.n2991623)=5.099997499998896
.nodeset v(xt1.n2991635)=-0.09999750000115205
.nodeset v(xt1.n2991643)=2.500001640050285
.nodeset v(xt1.n2991657)=2.500001640050285
.nodeset v(xt1.n2991667)=2.5000062202733
.nodeset v(xt1.n2991729)=2.499998749999496
.nodeset v(xt1.n2991741)=2.499998749999496
.nodeset v(xt1.n2991763)=2.49999874999964
.nodeset v(xt1.n2991765)=2.49999874999964
.nodeset v(xt1.n2991807)=62.4999987499995
.nodeset v(xt1.n2991809)=2.49999874999964
.nodeset v(xt1.n2991811)=2.49999874999964
.nodeset v(xt1.n2991831)=2.49999874999964
.nodeset v(xt1.n2991837)=2.49999874999964
.nodeset v(xt1.n2991849)=-57.5000012500005
.nodeset v(xt1.n2991901)=152.4999987499995
.nodeset v(xt1.n2991905)=2.49999874999964
.nodeset v(xt1.n2991907)=2.49999874999964
.nodeset v(xt1.n2991925)=2.49999874999964
.nodeset v(xt1.n2991931)=2.49999874999964
.nodeset v(xt1.n2991943)=-147.5000012500005
.nodeset v(xt1.n2991969)=4.376455993029402
.nodeset v(xt1.n2991997)=4.982524561913166
.nodeset v(xt1.n2992001)=0.01950485140263501
.nodeset v(xt1.n2992029)=0.01950485140263501
.nodeset v(xt1.n2992033)=4.982524561913166
.nodeset v(xt1.n2992093)=2.499998694889083
.nodeset v(xt1.n2992099)=2.499998694889908
.nodeset v(xt1.n2992105)=2.499998749999496
.nodeset v(xt1.n2992151)=2.816556805961792
.nodeset v(xt1.n2992163)=4.375929728073035
.nodeset v(xt1.n2992235)=4.375929728073035
.nodeset v(xt1.n2992267)=-50.62395986167806
.nodeset v(xt1.n2992287)=59.37604002810194
.nodeset v(xt1.n2992295)=-50.62395991678847
.nodeset v(xt1.n2992299)=-50.62395986167806
.nodeset v(xt1.n2992323)=59.37604002810194
.nodeset v(xt1.n2992331)=59.37604008321153
.nodeset v(xt1.n2992375)=2.499998749999496
.nodeset v(xt1.n2992397)=4.999997497498897
.nodeset v(xt1.n2992413)=2.502498844205694e-06
.nodeset v(xt1.n3201092)=28.70245538481055
.nodeset v(xt1.n3294524)=4.376040083067155
.nodeset v(xt1.n3294618)=4.376040083211525
.nodeset v(xt1.n3294626)=28.70245387505011
.nodeset v(xt1.n3294630)=14.97735905229048
.nodeset v(xt1.n3294682)=28.67500548805492
.nodeset v(xt1.n3294772)=2.49999875004402
.nodeset v(xt1.n3294776)=2.499998749999622
.nodeset v(xt1.n3827259)=28.6973351228748
.nodeset v(xt1.n3828449)=2.520939866204832
.nodeset v(xt1.n3850714)=2.501037249469892
.nodeset v(xt1.n3850724)=2.500001897469577
.nodeset v(xt1.n4031911)=4.376455993029402
.nodeset v(xt1.n4243633)=1.186000734139104
.nodeset v(xt1.n4736080)=5.991924090877371
.nodeset v(xt1.n4745674)=28.70245538481055
.nodeset v(xt1.n4747399)=28.70245538481054
.nodeset v(xt1.n4749239)=28.70245538481055
.nodeset v(xt1.n4796554)=28.70245538481055
.nodeset v(xt1.n4796572)=28.70245538481066
.nodeset v(xt1.n4797748)=28.70053029064897
.nodeset v(xt1.n4797760)=9.449588673713279
.nodeset v(xt1.n4798545)=28.69995276240046
.nodeset v(xt1.n4800105)=28.69995276240046
.nodeset v(xt1.n4809008)=2.499998750044028
.nodeset v(xt1.n4817896)=2.501037415115775
.nodeset v(xt1.n47456861)=28.70245538481055
.nodeset v(xt1.n47492651)=28.70245538481055
.nodeset v(xt1.n47965841)=28.70245538481066
.nodeset v(xt1.n48001371)=28.69995276240046
.nodeset v(xt1.sw_ol_opa4388)=2.499998749999496
.nodeset v(xt1.v11)=2.499998694889083
.nodeset v(xt1.v12)=2.499998694889908
.nodeset v(xt1.vcc_b)=4.999997499998896
.nodeset v(xt1.vcc_clp)=4.982524559430639
.nodeset v(xt1.vclp)=4.376040083211528
.nodeset v(xt1.vee_b)=2.499998847958193e-06
.nodeset v(xt1.vee_clp)=0.01950485388312889
.nodeset v(xt1.vimon)=2.816556805961792
.nodeset v(xt1.vout_s)=4.375929728073035
.nodeset v(xt1.vsense)=4.376455993029402
.nodeset v(xt1.x_u4.e1_int1)=-4.669999999999999e-06
.nodeset v(xt1.x_u6.g1_int1)=2.890050645021347e-06
.nodeset v(xt1.x_u10.gvo+_int1)=0
.nodeset v(xt1.x_u10.gvo-_int1)=0
.nodeset v(xt1.x_u11.gvo+_int1)=0
.nodeset v(xt1.x_u11.gvo-_int1)=0
.nodeset v(xt1.x_u12.gvo+_int1)=0
.nodeset v(xt1.x_u12.gvo-_int1)=0
.nodeset v(xt1.x_u16.gsw+_int1)=0
.nodeset v(xt1.x_u18.g1_int1)=1.747293820355134e-05
.nodeset v(xt1.x_u18.g1_int2)=0.3165580559622962
.nodeset v(xt1.x_u19.g1_int1)=1.950235140332581e-05
.nodeset v(xt1.x_u19.g1_int2)=-0.3165580559622962
.nodeset v(xt1.x_u22.g1_int1)=0
.nodeset v(xt1.x_u23.g1_int1)=0
.nodeset v(xt1.x_u26.g1_int1)=0.0003165580559622962
.nodeset v(xt1.x_u27.g1_int1)=0
.nodeset v(xt1.x_u30.g1_int1)=7.470477686975785e-12
.nodeset v(xt1.x_u31.g1_int1)=1.876458076810472e-06
.nodeset v(xt1.x_u32.g1_int1)=26.17639525667028
.nodeset v(xt1.x_u35.g1_int1)=-1.443289932012704e-13
.nodeset v(xt1.x_u38.3)=0
.nodeset v(xt1.x_u38.5)=0
.nodeset v(xt1.x_u39.3)=0
.nodeset v(xt1.x_u39.5)=0
.nodeset v(xt1.x_u40.5)=0
.nodeset v(xt2.cl_clamp)=4.376040083299976
.nodeset v(xt2.clamp)=4.376455993158743
.nodeset v(xt2.claw_clamp)=4.376040083299976
.nodeset v(xt2.esdn)=2.500001565345508
.nodeset v(xt2.esdp)=2.500000015250106
.nodeset v(xt2.mid)=2.499998749999496
.nodeset v(xt2.n2991553)=2.499998749999622
.nodeset v(xt2.n2991555)=2.499995345250106
.nodeset v(xt2.n2991563)=2.499995345060312
.nodeset v(xt2.n2991573)=2.500000015250106
.nodeset v(xt2.n2991579)=2.499995602981784
.nodeset v(xt2.n2991581)=2.500001897971614
.nodeset v(xt2.n2991583)=2.499995345060312
.nodeset v(xt2.n2991587)=2.500001640050141
.nodeset v(xt2.n2991619)=2.500001565345508
.nodeset v(xt2.n2991623)=5.099997499998896
.nodeset v(xt2.n2991635)=-0.09999750000115205
.nodeset v(xt2.n2991643)=2.500001640050286
.nodeset v(xt2.n2991657)=2.500001640050286
.nodeset v(xt2.n2991667)=2.5000062202733
.nodeset v(xt2.n2991729)=2.49999874999964
.nodeset v(xt2.n2991741)=2.49999874999964
.nodeset v(xt2.n2991763)=2.49999874999964
.nodeset v(xt2.n2991765)=2.49999874999964
.nodeset v(xt2.n2991807)=62.4999987499995
.nodeset v(xt2.n2991809)=2.49999874999964
.nodeset v(xt2.n2991811)=2.49999874999964
.nodeset v(xt2.n2991831)=2.49999874999964
.nodeset v(xt2.n2991837)=2.49999874999964
.nodeset v(xt2.n2991849)=-57.5000012500005
.nodeset v(xt2.n2991901)=152.4999987499995
.nodeset v(xt2.n2991905)=2.49999874999964
.nodeset v(xt2.n2991907)=2.49999874999964
.nodeset v(xt2.n2991925)=2.49999874999964
.nodeset v(xt2.n2991931)=2.49999874999964
.nodeset v(xt2.n2991943)=-147.5000012500005
.nodeset v(xt2.n2991969)=4.376455993262232
.nodeset v(xt2.n2991997)=4.982524561913031
.nodeset v(xt2.n2992001)=0.01950485140248162
.nodeset v(xt2.n2992029)=0.01950485140248162
.nodeset v(xt2.n2992033)=4.982524561913031
.nodeset v(xt2.n2992093)=2.499998694889082
.nodeset v(xt2.n2992099)=2.499998694889908
.nodeset v(xt2.n2992105)=2.499998749999496
.nodeset v(xt2.n2992151)=2.816556805976619
.nodeset v(xt2.n2992163)=4.375929728161479
.nodeset v(xt2.n2992235)=4.37592972816148
.nodeset v(xt2.n2992267)=-50.6239598615896
.nodeset v(xt2.n2992287)=59.3760400281904
.nodeset v(xt2.n2992295)=-50.62395991670002
.nodeset v(xt2.n2992299)=-50.6239598615896
.nodeset v(xt2.n2992323)=59.3760400281904
.nodeset v(xt2.n2992331)=59.37604008329998
.nodeset v(xt2.n2992375)=2.499998749999496
.nodeset v(xt2.n2992397)=4.999997497498897
.nodeset v(xt2.n2992413)=2.502498844205692e-06
.nodeset v(xt2.n3201092)=28.70245538609112
.nodeset v(xt2.n3294524)=4.376040083299934
.nodeset v(xt2.n3294618)=4.376040083299976
.nodeset v(xt2.n3294626)=28.70245387633068
.nodeset v(xt2.n3294630)=14.97735905290027
.nodeset v(xt2.n3294682)=28.67500548933413
.nodeset v(xt2.n3294772)=2.49999875004402
.nodeset v(xt2.n3294776)=2.499998749999622
.nodeset v(xt2.n3827259)=28.69733512415509
.nodeset v(xt2.n3828449)=2.520939866205855
.nodeset v(xt2.n3850714)=2.501037249469892
.nodeset v(xt2.n3850724)=2.500001897469577
.nodeset v(xt2.n4031911)=4.376455993262232
.nodeset v(xt2.n4243633)=1.186000734139104
.nodeset v(xt2.n4736080)=5.991924091310647
.nodeset v(xt2.n4745674)=28.70245538609111
.nodeset v(xt2.n4747399)=28.70245538609111
.nodeset v(xt2.n4749239)=28.70245538609111
.nodeset v(xt2.n4796554)=28.70245538609111
.nodeset v(xt2.n4796572)=28.7024553860912
.nodeset v(xt2.n4797748)=28.70053029192941
.nodeset v(xt2.n4797760)=9.449588674052913
.nodeset v(xt2.n4798545)=28.69995276368088
.nodeset v(xt2.n4800105)=28.69995276368088
.nodeset v(xt2.n4809008)=2.499998750044028
.nodeset v(xt2.n4817896)=2.501037415115775
.nodeset v(xt2.n47456861)=28.70245538609111
.nodeset v(xt2.n47492651)=28.70245538609111
.nodeset v(xt2.n47965841)=28.7024553860912
.nodeset v(xt2.n48001371)=28.69995276368088
.nodeset v(xt2.sw_ol_opa4388)=2.499998749999496
.nodeset v(xt2.v11)=2.499998694889082
.nodeset v(xt2.v12)=2.499998694889908
.nodeset v(xt2.vcc_b)=4.999997499998896
.nodeset v(xt2.vcc_clp)=4.982524559430504
.nodeset v(xt2.vclp)=4.376040083299984
.nodeset v(xt2.vee_b)=2.499998847958191e-06
.nodeset v(xt2.vee_clp)=0.01950485388297551
.nodeset v(xt2.vimon)=2.816556805976619
.nodeset v(xt2.vout_s)=4.375929728161479
.nodeset v(xt2.vsense)=4.376455993262232
.nodeset v(xt2.x_u4.e1_int1)=-4.669999999999999e-06
.nodeset v(xt2.x_u6.g1_int1)=2.890050645909525e-06
.nodeset v(xt2.x_u10.gvo+_int1)=0
.nodeset v(xt2.x_u10.gvo-_int1)=0
.nodeset v(xt2.x_u11.gvo+_int1)=0
.nodeset v(xt2.x_u11.gvo-_int1)=0
.nodeset v(xt2.x_u12.gvo+_int1)=0
.nodeset v(xt2.x_u12.gvo-_int1)=0
.nodeset v(xt2.x_u16.gsw+_int1)=0
.nodeset v(xt2.x_u18.g1_int1)=1.747293820368655e-05
.nodeset v(xt2.x_u18.g1_int2)=0.3165580559771231
.nodeset v(xt2.x_u19.g1_int1)=1.950235140317243e-05
.nodeset v(xt2.x_u19.g1_int2)=-0.3165580559771231
.nodeset v(xt2.x_u22.g1_int1)=0
.nodeset v(xt2.x_u23.g1_int1)=0
.nodeset v(xt2.x_u26.g1_int1)=0.0003165580559771229
.nodeset v(xt2.x_u27.g1_int1)=0
.nodeset v(xt2.x_u30.g1_int1)=7.470477795396002e-12
.nodeset v(xt2.x_u31.g1_int1)=1.876458077032517e-06
.nodeset v(xt2.x_u32.g1_int1)=26.17639525794948
.nodeset v(xt2.x_u35.g1_int1)=0
.nodeset v(xt2.x_u38.3)=0
.nodeset v(xt2.x_u38.5)=0
.nodeset v(xt2.x_u39.3)=0
.nodeset v(xt2.x_u39.5)=0
.nodeset v(xt2.x_u40.5)=0
.nodeset v(xt3.cl_clamp)=4.376040083271758
.nodeset v(xt3.clamp)=4.376455993275158
.nodeset v(xt3.claw_clamp)=4.376040083271758
.nodeset v(xt3.esdn)=2.500001565345508
.nodeset v(xt3.esdp)=2.500000015250105
.nodeset v(xt3.mid)=2.499998749999496
.nodeset v(xt3.n2991553)=2.499998749999622
.nodeset v(xt3.n2991555)=2.499995345250105
.nodeset v(xt3.n2991563)=2.499995345060311
.nodeset v(xt3.n2991573)=2.500000015250105
.nodeset v(xt3.n2991579)=2.499995602981784
.nodeset v(xt3.n2991581)=2.500001897971614
.nodeset v(xt3.n2991583)=2.499995345060311
.nodeset v(xt3.n2991587)=2.500001640050141
.nodeset v(xt3.n2991619)=2.500001565345508
.nodeset v(xt3.n2991623)=5.099997499998896
.nodeset v(xt3.n2991635)=-0.09999750000115205
.nodeset v(xt3.n2991643)=2.500001640050141
.nodeset v(xt3.n2991657)=2.500001640050141
.nodeset v(xt3.n2991667)=2.5000062202733
.nodeset v(xt3.n2991729)=2.49999874999964
.nodeset v(xt3.n2991741)=2.49999874999964
.nodeset v(xt3.n2991763)=2.499998749999496
.nodeset v(xt3.n2991765)=2.499998749999496
.nodeset v(xt3.n2991807)=62.4999987499995
.nodeset v(xt3.n2991809)=2.49999874999964
.nodeset v(xt3.n2991811)=2.49999874999964
.nodeset v(xt3.n2991831)=2.49999874999964
.nodeset v(xt3.n2991837)=2.49999874999964
.nodeset v(xt3.n2991849)=-57.5000012500005
.nodeset v(xt3.n2991901)=152.4999987499995
.nodeset v(xt3.n2991905)=2.49999874999964
.nodeset v(xt3.n2991907)=2.49999874999964
.nodeset v(xt3.n2991925)=2.49999874999964
.nodeset v(xt3.n2991931)=2.49999874999964
.nodeset v(xt3.n2991943)=-147.5000012500005
.nodeset v(xt3.n2991969)=4.376455993378648
.nodeset v(xt3.n2991997)=4.982524561913074
.nodeset v(xt3.n2992001)=0.01950485140253055
.nodeset v(xt3.n2992029)=0.01950485140253055
.nodeset v(xt3.n2992033)=4.982524561913074
.nodeset v(xt3.n2992093)=2.499998694889081
.nodeset v(xt3.n2992099)=2.49999869488991
.nodeset v(xt3.n2992105)=2.499998749999496
.nodeset v(xt3.n2992151)=2.816556805971889
.nodeset v(xt3.n2992163)=4.375929728133263
.nodeset v(xt3.n2992235)=4.375929728133263
.nodeset v(xt3.n2992267)=-50.62395986161782
.nodeset v(xt3.n2992287)=59.37604002816218
.nodeset v(xt3.n2992295)=-50.62395991672823
.nodeset v(xt3.n2992299)=-50.62395986161782
.nodeset v(xt3.n2992323)=59.37604002816218
.nodeset v(xt3.n2992331)=59.37604008327177
.nodeset v(xt3.n2992375)=2.499998749999496
.nodeset v(xt3.n2992397)=4.999997497498897
.nodeset v(xt3.n2992413)=2.502498844205695e-06
.nodeset v(xt3.n3201092)=28.70245538585829
.nodeset v(xt3.n3294524)=4.376040083416323
.nodeset v(xt3.n3294618)=4.376040083271758
.nodeset v(xt3.n3294626)=28.70245387609785
.nodeset v(xt3.n3294630)=14.9773590527894
.nodeset v(xt3.n3294682)=28.6750054891013
.nodeset v(xt3.n3294772)=2.49999875004402
.nodeset v(xt3.n3294776)=2.499998749999622
.nodeset v(xt3.n3827259)=28.6973351239223
.nodeset v(xt3.n3828449)=2.520939866205669
.nodeset v(xt3.n3850714)=2.501037249469892
.nodeset v(xt3.n3850724)=2.500001897469577
.nodeset v(xt3.n4031911)=4.376455993378648
.nodeset v(xt3.n4243633)=1.186000734139104
.nodeset v(xt3.n4736080)=5.991924091527288
.nodeset v(xt3.n4745674)=28.70245538585828
.nodeset v(xt3.n4747399)=28.70245538585828
.nodeset v(xt3.n4749239)=28.70245538585828
.nodeset v(xt3.n4796554)=28.70245538585828
.nodeset v(xt3.n4796572)=28.70245538585837
.nodeset v(xt3.n4797748)=28.7005302916966
.nodeset v(xt3.n4797760)=9.44958867399116
.nodeset v(xt3.n4798545)=28.69995276344807
.nodeset v(xt3.n4800105)=28.69995276344807
.nodeset v(xt3.n4809008)=2.499998750044028
.nodeset v(xt3.n4817896)=2.501037415115775
.nodeset v(xt3.n47456861)=28.70245538585828
.nodeset v(xt3.n47492651)=28.70245538585828
.nodeset v(xt3.n47965841)=28.70245538585837
.nodeset v(xt3.n48001371)=28.69995276344807
.nodeset v(xt3.sw_ol_opa4388)=2.499998749999496
.nodeset v(xt3.v11)=2.499998694889081
.nodeset v(xt3.v12)=2.49999869488991
.nodeset v(xt3.vcc_b)=4.999997499998896
.nodeset v(xt3.vcc_clp)=4.982524559430548
.nodeset v(xt3.vclp)=4.376040083271768
.nodeset v(xt3.vee_b)=2.499998847958194e-06
.nodeset v(xt3.vee_clp)=0.01950485388302444
.nodeset v(xt3.vimon)=2.816556805971889
.nodeset v(xt3.vout_s)=4.375929728133263
.nodeset v(xt3.vsense)=4.376455993378648
.nodeset v(xt3.x_u4.e1_int1)=-4.669999999999999e-06
.nodeset v(xt3.x_u6.g1_int1)=2.890050645021347e-06
.nodeset v(xt3.x_u10.gvo+_int1)=0
.nodeset v(xt3.x_u10.gvo-_int1)=0
.nodeset v(xt3.x_u11.gvo+_int1)=0
.nodeset v(xt3.x_u11.gvo-_int1)=0
.nodeset v(xt3.x_u12.gvo+_int1)=0
.nodeset v(xt3.x_u12.gvo-_int1)=0
.nodeset v(xt3.x_u16.gsw+_int1)=0
.nodeset v(xt3.x_u18.g1_int1)=1.747293820364341e-05
.nodeset v(xt3.x_u18.g1_int2)=0.3165580559723931
.nodeset v(xt3.x_u19.g1_int1)=1.950235140322137e-05
.nodeset v(xt3.x_u19.g1_int2)=-0.3165580559723931
.nodeset v(xt3.x_u22.g1_int1)=0
.nodeset v(xt3.x_u23.g1_int1)=0
.nodeset v(xt3.x_u26.g1_int1)=0.0003165580559723932
.nodeset v(xt3.x_u27.g1_int1)=0
.nodeset v(xt3.x_u30.g1_int1)=7.470463267086891e-12
.nodeset v(xt3.x_u31.g1_int1)=1.876458076810472e-06
.nodeset v(xt3.x_u32.g1_int1)=26.1763952577171
.nodeset v(xt3.x_u35.g1_int1)=1.443289932012704e-13
.nodeset v(xt3.x_u38.3)=0
.nodeset v(xt3.x_u38.5)=0
.nodeset v(xt3.x_u39.3)=0
.nodeset v(xt3.x_u39.5)=0
.nodeset v(xt3.x_u40.5)=0
.control
set wr_singlescale
set wr_vecnames
set numdgt=15
optran 1 1 1 200n 100u 0
op
wrdata op.txt v(vcm) v(vexc) v(vexcmd) v(cmdrv) v(exdrv) v(row0) v(row1) v(row2) v(row3) v(col0) v(col1) v(col2) v(col3) v(drv0) v(drv1) v(drv2) v(drv3) v(tdrv0) v(tdrv1) v(tdrv2) v(tdrv3) v(tap0) v(tap1) v(tap2) v(tap3) v(ain0) v(ain1) v(ain2) v(ain3)
ac dec 80 1 100meg
wrdata ac.txt v(vcm) v(vexc) v(vexcmd) v(cmdrv) v(exdrv) v(row0) v(row1) v(row2) v(row3) v(col0) v(col1) v(col2) v(col3) v(drv0) v(drv1) v(drv2) v(drv3) v(tdrv0) v(tdrv1) v(tdrv2) v(tdrv3) v(tap0) v(tap1) v(tap2) v(tap3) v(ain0) v(ain1) v(ain2) v(ain3)
quit
.endc
.end
