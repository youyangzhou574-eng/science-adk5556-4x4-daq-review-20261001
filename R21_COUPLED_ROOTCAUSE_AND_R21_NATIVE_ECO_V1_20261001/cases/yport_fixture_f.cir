Port admittance fixture f
RIN minus 0 100k
ROUT fb 0 1k
EGAIN z 0 minus 0 100
RP z pole 1k
CP pole 0 159.1549431n
GOUT fb 0 pole 0 1m
LDC minus fb 1e12
VE ep 0 DC 0 AC 0
VF fp 0 DC 0 AC 1
CE ep minus 1e12
CFPORT fp fb 1e12
.control
set wr_singlescale
set wr_vecnames
set numdgt=15
op
wrdata op.txt v(minus) v(fb)
ac dec 100 1 100meg
let yer=real(-i(VE))
let yei=imag(-i(VE))
let yfr=real(-i(VF))
let yfi=imag(-i(VF))
wrdata ac.txt yer yei yfr yfi
quit
.endc
.end
