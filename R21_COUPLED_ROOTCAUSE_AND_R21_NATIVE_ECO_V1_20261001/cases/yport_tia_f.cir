Port admittance tia f
.include "../../models/OPA4388_ORIGINAL.LIB"
V5 v5 0 5
VCM vcm 0 2.5
X1 vcm minus v5 0 drv OPA4388
RISO drv tap 1k
RSENSE col fb 10k
RF tap col 4.99k
CF tap col 2.2n
RARRAY col row 200
VROW row 0 2.4375
CL col 0 1n
RADC tap ain 100
CADC ain 0 10n
RIN ain 0 1meg
CHF drv fb 22p
LDC minus fb 1e12
VE ep 0 DC 0 AC 0
VF fp 0 DC 0 AC 1
CE ep minus 1e12
CFPORT fp fb 1e12
.control
set wr_singlescale
set wr_vecnames
set numdgt=15
optran 0 0 0 200n 2m 0
op
wrdata op.txt v(minus) v(fb) v(drv)
ac dec 100 1 100meg
let yer=real(-i(VE))
let yei=imag(-i(VE))
let yfr=real(-i(VF))
let yfi=imag(-i(VF))
wrdata ac.txt yer yei yfr yfi
quit
.endc
.end
