Port admittance row e
.include "../../models/OPA4388_ORIGINAL.LIB"
V5 v5 0 5
VCM vcm 0 2.5
VCMD cmd 0 2.25
X1 cmd minus v5 0 drv OPA4388
RISO drv row 1k
RFB row fb 4.99k
CHF drv fb 100p
RLOAD row vcm 200
CL row 0 1n
LDC minus fb 1e12
VE ep 0 DC 0 AC 1
VF fp 0 DC 0 AC 0
CE ep minus 1e12
CFPORT fp fb 1e12
.control
set wr_singlescale
set wr_vecnames
set numdgt=15
optran 0 0 0 200n 2m 0
op
wrdata op.txt v(minus) v(fb) v(drv)
ac dec 100 1 100meg
let yer=real(-i(VE))
let yei=imag(-i(VE))
let yfr=real(-i(VF))
let yfi=imag(-i(VF))
wrdata ac.txt yer yei yfr yfi
quit
.endc
.end
