loop_tia_v
.include "../../models/OPA4388_ORIGINAL.LIB"
V5 v5 0 5
VCM vcm 0 2.5
VTEST minus fb DC 0 AC 1
ITEST 0 minus DC 0 AC 0
X1 vcm minus v5 0 drv OPA4388
RISO drv tap 1k
RSENSE col fb 10k
RF tap col 4.99k
CF tap col 2.2n
RARRAY col row 200
VROW row 0 2.4375
CL col 0 1n
RADC tap ain 100
CADC ain 0 10n
RIN ain 0 1meg
CHF drv fb 22p
.control
set wr_singlescale
set wr_vecnames
optran 0 0 0 200n 2m 0
op
wrdata op.txt v(minus) v(fb) v(drv)
set filetype=ascii
write op.raw all
quit
.endc
.end
