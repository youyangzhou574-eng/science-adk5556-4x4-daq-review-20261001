Port admittance vcm f
.include "../../models/OPAx388.LIB"
V5 v5 0 5
VCM vcm 0 2.5
VCMD cmd 0 2.5
X1 cmd minus v5 0 drv OPAx388
RISO drv tap 1k
RFB tap fb 4.99k
CHF drv fb 100p
CL tap 0 1n
RLOAD tap 0 1meg
LDC minus fb 1e9
VE ep 0 DC 0 AC 0
VF fp 0 DC 0 AC 1
CE ep minus 1m
CFPORT fp fb 1m
.control
set wr_singlescale
set wr_vecnames
set numdgt=15
op
wrdata op.txt v(minus) v(fb) v(drv)
ac dec 100 1 100meg
let yer=real(-i(VE))
let yei=imag(-i(VE))
let yfr=real(-i(VF))
let yfi=imag(-i(VF))
let er=real(v(minus))
let ei=imag(v(minus))
let fr=real(v(fb))
let fi=imag(v(fb))
wrdata ac.txt yer yei yfr yfi er ei fr fi
quit
.endc
.end
