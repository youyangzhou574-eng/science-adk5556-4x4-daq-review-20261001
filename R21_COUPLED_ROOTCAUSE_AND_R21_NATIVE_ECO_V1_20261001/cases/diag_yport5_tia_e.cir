Port admittance tia e
.include "../../models/OPA4388_ORIGINAL.LIB"
V5 v5 0 5
VCM vcm 0 2.5
X1 vcm minus v5 0 drv OPA4388
RISO drv tap 1k
RSENSE col fb 10k
RF tap col 4.99k
CF tap col 2.2n
RARRAY col row 200
VROW row 0 2.4375
CL col 0 1n
RADC tap ain 100
CADC ain 0 10n
RIN ain 0 1meg
CHF drv fb 22p
LDC minus fb 1e9
VE ep 0 DC 0 AC 1
VF fp 0 DC 0 AC 0
CE ep minus 1u
CFPORT fp fb 1u
.nodeset v(v5)=5
.nodeset v(ain)=4.059004743625663
.nodeset v(col)=2.500001381146061
.nodeset v(drv)=4.376086446557141
.nodeset v(fb)=2.500084466623637
.nodeset v(minus)=2.500084466623637
.nodeset v(row)=2.4375
.nodeset v(tap)=4.059410644017099
.nodeset v(vcm)=2.5
.nodeset v(x1.cl_clamp)=4.376085821096186
.nodeset v(x1.clamp)=4.377053998929863
.nodeset v(x1.claw_clamp)=4.376085821096185
.nodeset v(x1.esdn)=2.500093531003807
.nodeset v(x1.esdp)=2.499998527989659
.nodeset v(x1.mid)=0.004994998334161251
.nodeset v(x1.n2991553)=0.004995230223560632
.nodeset v(x1.n2991555)=2.499993857989659
.nodeset v(x1.n2991563)=2.499994089689137
.nodeset v(x1.n2991573)=2.499998527989659
.nodeset v(x1.n2991579)=0.00499495477634998
.nodeset v(x1.n2991581)=0.00500128911542827
.nodeset v(x1.n2991583)=2.499994089689137
.nodeset v(x1.n2991587)=2.500000424028216
.nodeset v(x1.n2991619)=2.500093531003807
.nodeset v(x1.n2991623)=5.099995014691678
.nodeset v(x1.n2991635)=-0.09999999492523752
.nodeset v(x1.n2991643)=2.500000447060052
.nodeset v(x1.n2991657)=2.500000447083084
.nodeset v(x1.n2991667)=-0.0043133937381441
.nodeset v(x1.n2991729)=0.0049949983372881
.nodeset v(x1.n2991741)=0.004994998337291227
.nodeset v(x1.n2991763)=0.004994999222453739
.nodeset v(x1.n2991765)=0.004994999223342031
.nodeset v(x1.n2991807)=60.00499499833416
.nodeset v(x1.n2991809)=0.004994998334161773
.nodeset v(x1.n2991811)=0.004994998334161773
.nodeset v(x1.n2991831)=0.004994998334161773
.nodeset v(x1.n2991837)=0.004994998334161773
.nodeset v(x1.n2991849)=-59.99500500166584
.nodeset v(x1.n2991901)=150.0049949983342
.nodeset v(x1.n2991905)=0.004994998334161773
.nodeset v(x1.n2991907)=0.004994998334161773
.nodeset v(x1.n2991925)=0.004994998334161773
.nodeset v(x1.n2991931)=0.004994998334161773
.nodeset v(x1.n2991943)=-149.9950050016658
.nodeset v(x1.n2991969)=4.377054003926324
.nodeset v(x1.n2991997)=4.982531064788401
.nodeset v(x1.n2992001)=0.01950229302938743
.nodeset v(x1.n2992029)=0.0195022930294669
.nodeset v(x1.n2992033)=4.982531064797515
.nodeset v(x1.n2992093)=0.004994943223190333
.nodeset v(x1.n2992099)=0.00499494322513228
.nodeset v(x1.n2992105)=0.004994998334161251
.nodeset v(x1.n2992151)=-0.5847589000386864
.nodeset v(x1.n2992163)=4.376086446557141
.nodeset v(x1.n2992235)=4.376086446557141
.nodeset v(x1.n2992267)=-50.62391498493795
.nodeset v(x1.n2992287)=59.37608490484205
.nodeset v(x1.n2992295)=-50.62391504004892
.nodeset v(x1.n2992299)=-50.62391498493795
.nodeset v(x1.n2992323)=59.37608490484205
.nodeset v(x1.n2992331)=59.37608495995108
.nodeset v(x1.n2992375)=0.004994998334161251
.nodeset v(x1.n2992397)=4.999995009697261
.nodeset v(x1.n2992413)=5.07975767528156e-09
.nodeset v(x1.n3201092)=-0.7046169505448944
.nodeset v(x1.n3294524)=4.376084935045381
.nodeset v(x1.n3294618)=4.376085821096186
.nodeset v(x1.n3294626)=-0.1434834960382432
.nodeset v(x1.n3294630)=-0.3332715239582923
.nodeset v(x1.n3294682)=37.76630770726091
.nodeset v(x1.n3294772)=0.005082797507494526
.nodeset v(x1.n3294776)=0.004995247795545513
.nodeset v(x1.n3827259)=53.66396463331403
.nodeset v(x1.n3828449)=0.03520557491141744
.nodeset v(x1.n3850714)=0.007069921320270135
.nodeset v(x1.n3850724)=0.005001286886883024
.nodeset v(x1.n4031911)=4.37705399630438
.nodeset v(x1.n4243633)=0.002369630058891038
.nodeset v(x1.n4736080)=8.141020300022138
.nodeset v(x1.n4745674)=46.20161101808407
.nodeset v(x1.n4747399)=46.20164841622896
.nodeset v(x1.n4749239)=53.30729594660672
.nodeset v(x1.n4796554)=53.30729642688805
.nodeset v(x1.n4796572)=53.67711305307113
.nodeset v(x1.n4797748)=53.67317073879012
.nodeset v(x1.n4797760)=14.23674955283659
.nodeset v(x1.n4798545)=53.65871057184668
.nodeset v(x1.n4800105)=53.66774095538619
.nodeset v(x1.n4809008)=0.005082775658812766
.nodeset v(x1.n4817896)=0.007070220711653086
.nodeset v(x1.n47456861)=53.67909036905313
.nodeset v(x1.n47492651)=53.68127739557396
.nodeset v(x1.n47965841)=53.68191586639818
.nodeset v(x1.n48001371)=53.67677133892571
.nodeset v(x1.sw_ol_opa4388)=0.004994998334161251
.nodeset v(x1.v11)=0.004994943223190329
.nodeset v(x1.v12)=0.004994943225132283
.nodeset v(x1.vcc_b)=4.999995014691678
.nodeset v(x1.vcc_clp)=4.982531059819979
.nodeset v(x1.vclp)=4.376084959951077
.nodeset v(x1.vee_b)=5.074762490972225e-09
.nodeset v(x1.vee_clp)=0.01950229301495961
.nodeset v(x1.vimon)=0.3215668698857863
.nodeset v(x1.vout_s)=4.375976764202269
.nodeset v(x1.vsense)=4.37705400392632
.nodeset v(x1.x_u4.e1_int1)=-4.669999999999999e-06
.nodeset v(x1.x_u6.g1_int1)=2.495005425694055
.nodeset v(x1.x_u10.gvo+_int1)=0
.nodeset v(x1.x_u10.gvo-_int1)=0
.nodeset v(x1.x_u11.gvo+_int1)=0
.nodeset v(x1.x_u11.gvo-_int1)=0
.nodeset v(x1.x_u12.gvo+_int1)=0
.nodeset v(x1.x_u12.gvo-_int1)=0
.nodeset v(x1.x_u16.gsw+_int1)=0
.nodeset v(x1.x_u18.g1_int1)=1.747306418999948e-05
.nodeset v(x1.x_u18.g1_int2)=0.3165718715516251
.nodeset v(x1.x_u19.g1_int1)=1.95022084814383e-05
.nodeset v(x1.x_u19.g1_int2)=-0.3165718715516251
.nodeset v(x1.x_u22.g1_int1)=0
.nodeset v(x1.x_u23.g1_int1)=0
.nodeset v(x1.x_u26.g1_int1)=0.0003165718715516251
.nodeset v(x1.x_u27.g1_int1)=0
.nodeset v(x1.x_u30.g1_int1)=-9.308392072329003e-09
.nodeset v(x1.x_u31.g1_int1)=-0.002338175004642381
.nodeset v(x1.x_u32.g1_int1)=37.76322072157022
.nodeset v(x1.x_u35.g1_int1)=-8.860508039082449e-10
.nodeset v(x1.x_u38.3)=0
.nodeset v(x1.x_u38.5)=0
.nodeset v(x1.x_u39.3)=0
.nodeset v(x1.x_u39.5)=0
.nodeset v(x1.x_u40.5)=0
.options rseries=1e-4
.control
set wr_singlescale
set wr_vecnames
set numdgt=15
op
wrdata op.txt v(minus) v(fb) v(drv)
ac dec 100 1 100meg
let yer=real(-i(VE))
let yei=imag(-i(VE))
let yfr=real(-i(VF))
let yfi=imag(-i(VF))
let er=real(v(minus))
let ei=imag(v(minus))
let fr=real(v(fb))
let fi=imag(v(fb))
wrdata ac.txt yer yei yfr yfi er ei fr fi
quit
.endc
.end
