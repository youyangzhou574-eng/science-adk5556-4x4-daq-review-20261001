Nominal row loop revision 1
.include "../../models/OPA4388_ORIGINAL.LIB"
V5 v5 0 5
VCM vcm 0 2.5
VTEST minus fb DC 0 AC 1
VCMD cmd 0 2.25
X1 cmd minus v5 0 drv OPA4388
RISO drv row 1k
RFB row fb 4.99k
CHF drv fb 100p
RLOAD row vcm 200
CL row 0 1n
.control
set wr_singlescale
set wr_vecnames
optran 0 0 0 200n 2m 0
op
wrdata op.txt v(drv) v(minus) v(fb)
ac dec 100 1 100meg
let loop=-v(fb)/v(minus)
let loop_real=real(loop)
let loop_imag=imag(loop)
wrdata loop.txt loop_real loop_imag
quit
.endc
.end
