mimo_blank_800_p10
.include "../../models/OPA4388_ORIGINAL.LIB"
.include "../../models/OPAx388.LIB"
V5 v5 0 5.0
VREF ref 0 DC 2.5 AC 0
RCM_IN ref vcm_cmd 1k
XCM vcm_cmd e0 v5 0 cmdrv OPAx388
RCMISO cmdrv vcm 1k
RCMFB vcm cmfb 4.99k
CCMHF cmdrv cmfb 100p
CCML vcm 0 1n
RUP vcm vexcmd 10k
RDN vexcmd 0 90k
XEX vexcmd e1 v5 0 exdrv OPAx388
REXISO exdrv vexc 1k
REXFB vexc exfb 4.99k
CEXHF exdrv exfb 100p
CEXL vexc 0 1n
.model MUX SW(Ron=5 Roff=1e12 Vt=.5 Vh=.1)
VSEL0 sel0 0 0
BNS0 ns0 0 V=1-V(sel0)
SA0 vexc cmd0 sel0 0 MUX
SB0 vcm cmd0 ns0 0 MUX
XR0 cmd0 e2 v5 0 drv0 OPA4388
RISO0 drv0 row0 1k
RFB0 row0 fb0 4.99k
CHF0 drv0 fb0 100p
CLROW0 row0 0 1n
VSEL1 sel1 0 0
BNS1 ns1 0 V=1-V(sel1)
SA1 vexc cmd1 sel1 0 MUX
SB1 vcm cmd1 ns1 0 MUX
XR1 cmd1 e3 v5 0 drv1 OPA4388
RISO1 drv1 row1 1k
RFB1 row1 fb1 4.99k
CHF1 drv1 fb1 100p
CLROW1 row1 0 1n
VSEL2 sel2 0 0
BNS2 ns2 0 V=1-V(sel2)
SA2 vexc cmd2 sel2 0 MUX
SB2 vcm cmd2 ns2 0 MUX
XR2 cmd2 e4 v5 0 drv2 OPA4388
RISO2 drv2 row2 1k
RFB2 row2 fb2 4.99k
CHF2 drv2 fb2 100p
CLROW2 row2 0 1n
VSEL3 sel3 0 0
BNS3 ns3 0 V=1-V(sel3)
SA3 vexc cmd3 sel3 0 MUX
SB3 vcm cmd3 ns3 0 MUX
XR3 cmd3 e5 v5 0 drv3 OPA4388
RISO3 drv3 row3 1k
RFB3 row3 fb3 4.99k
CHF3 drv3 fb3 100p
CLROW3 row3 0 1n
XT0 vcm e6 v5 0 tdrv0 OPA4388
RSENSE0 col0 minus0 10k
RTISO0 tdrv0 tap0 1k
RF0 tap0 col0 4.99k
CF0 tap0 col0 2.2n
CHFT0 tdrv0 minus0 22p
RADC0 tap0 ain0 100
CADC0 ain0 0 10n
RIN0 ain0 0 1meg
CLCOL0 col0 0 1n
RA0_0 row0 col0 800
RA1_0 row1 col0 800
RA2_0 row2 col0 800
RA3_0 row3 col0 800
XT1 vcm e7 v5 0 tdrv1 OPA4388
RSENSE1 col1 minus1 10k
RTISO1 tdrv1 tap1 1k
RF1 tap1 col1 4.99k
CF1 tap1 col1 2.2n
CHFT1 tdrv1 minus1 22p
RADC1 tap1 ain1 100
CADC1 ain1 0 10n
RIN1 ain1 0 1meg
CLCOL1 col1 0 1n
RA0_1 row0 col1 800
RA1_1 row1 col1 800
RA2_1 row2 col1 800
RA3_1 row3 col1 800
XT2 vcm e8 v5 0 tdrv2 OPA4388
RSENSE2 col2 minus2 10k
RTISO2 tdrv2 tap2 1k
RF2 tap2 col2 4.99k
CF2 tap2 col2 2.2n
CHFT2 tdrv2 minus2 22p
RADC2 tap2 ain2 100
CADC2 ain2 0 10n
RIN2 ain2 0 1meg
CLCOL2 col2 0 1n
RA0_2 row0 col2 800
RA1_2 row1 col2 800
RA2_2 row2 col2 800
RA3_2 row3 col2 800
XT3 vcm e9 v5 0 tdrv3 OPA4388
RSENSE3 col3 minus3 10k
RTISO3 tdrv3 tap3 1k
RF3 tap3 col3 4.99k
CF3 tap3 col3 2.2n
CHFT3 tdrv3 minus3 22p
RADC3 tap3 ain3 100
CADC3 ain3 0 10n
RIN3 ain3 0 1meg
CLCOL3 col3 0 1n
RA0_3 row0 col3 800
RA1_3 row1 col3 800
RA2_3 row2 col3 800
RA3_3 row3 col3 800
.options method=trap
LDC0 e0 cmfb 1e9
LDC1 e1 exfb 1e9
LDC2 e2 fb0 1e9
LDC3 e3 fb1 1e9
LDC4 e4 fb2 1e9
LDC5 e5 fb3 1e9
LDC6 e6 minus0 1e9
LDC7 e7 minus1 1e9
LDC8 e8 minus2 1e9
LDC9 e9 minus3 1e9
.nodeset v(v5)=5
.nodeset v(ain0)=2.49974734862602
.nodeset v(ain1)=2.49974735508348
.nodeset v(ain2)=2.49974734852939
.nodeset v(ain3)=2.49974734864947
.nodeset v(cmd0)=2.50000001521483
.nodeset v(cmd1)=2.50000001521492
.nodeset v(cmd2)=2.50000001521595
.nodeset v(cmd3)=2.50000001521484
.nodeset v(cmdrv)=2.52500025215156
.nodeset v(cmfb)=2.50000016912203
.nodeset v(col0)=2.50000133178892
.nodeset v(col1)=2.50000133203631
.nodeset v(col2)=2.50000133178892
.nodeset v(col3)=2.50000133178892
.nodeset v(drv0)=2.50000222737764
.nodeset v(drv1)=2.50000222714516
.nodeset v(drv2)=2.50000222877444
.nodeset v(drv3)=2.50000222714516
.nodeset v(exdrv)=2.24999974616182
.nodeset v(exfb)=2.24999993888856
.nodeset v(fb0)=2.50000164001882
.nodeset v(fb1)=2.50000163999004
.nodeset v(fb2)=2.50000164025227
.nodeset v(fb3)=2.50000163999066
.nodeset v(minus0)=2.50000164006316
.nodeset v(minus1)=2.50000164031052
.nodeset v(minus2)=2.50000164006316
.nodeset v(minus3)=2.50000164006316
.nodeset v(ns0)=1
.nodeset v(ns1)=1
.nodeset v(ns2)=1
.nodeset v(ns3)=1
.nodeset v(ref)=2.5
.nodeset v(row0)=2.500001486235
.nodeset v(row1)=2.50000148620621
.nodeset v(row2)=2.50000148646845
.nodeset v(row3)=2.50000148620683
.nodeset v(sel0)=0
.nodeset v(sel1)=0
.nodeset v(sel2)=0
.nodeset v(sel3)=0
.nodeset v(tap0)=2.49999732336089
.nodeset v(tap1)=2.49999732981899
.nodeset v(tap2)=2.49999732326424
.nodeset v(tap3)=2.49999732338434
.nodeset v(tdrv0)=2.50249626741732
.nodeset v(tdrv1)=2.50249627512652
.nodeset v(tdrv2)=2.50249626730121
.nodeset v(tdrv3)=2.50249626744549
.nodeset v(vcm)=2.50000001536682
.nodeset v(vcm_cmd)=2.49999997008045
.nodeset v(vexc)=2.24999977924267
.nodeset v(vexcmd)=2.24999975409644
.nodeset v(xcm.cl_clamp)=2.52500325618064
.nodeset v(xcm.clamp)=2.52500879950821
.nodeset v(xcm.claw_clamp)=2.52500325618064
.nodeset v(xcm.esdn)=2.50000016912234
.nodeset v(xcm.esdp)=2.49999997008015
.nodeset v(xcm.mid)=2.4999987499995
.nodeset v(xcm.n2991553)=2.49999874999962
.nodeset v(xcm.n2991555)=2.49999966987815
.nodeset v(xcm.n2991563)=2.49999966993739
.nodeset v(xcm.n2991573)=2.49999997008015
.nodeset v(xcm.n2991579)=2.49999849987203
.nodeset v(xcm.n2991581)=2.49999900005663
.nodeset v(xcm.n2991583)=2.49999966993739
.nodeset v(xcm.n2991587)=2.500000170122
.nodeset v(xcm.n2991619)=2.50000016912234
.nodeset v(xcm.n2991623)=5.09999749999889
.nodeset v(xcm.n2991635)=-0.099997500001152
.nodeset v(xcm.n2991643)=2.500000170122
.nodeset v(xcm.n2991657)=2.500000170122
.nodeset v(xcm.n2991667)=2.4999988495658
.nodeset v(xcm.n2991729)=2.4999987499995
.nodeset v(xcm.n2991741)=2.4999987499995
.nodeset v(xcm.n2991763)=2.4999987499995
.nodeset v(xcm.n2991765)=2.4999987499995
.nodeset v(xcm.n2991807)=62.4999987499995
.nodeset v(xcm.n2991809)=2.4999987499995
.nodeset v(xcm.n2991811)=2.4999987499995
.nodeset v(xcm.n2991831)=2.4999987499995
.nodeset v(xcm.n2991837)=2.4999987499995
.nodeset v(xcm.n2991849)=-57.5000012500005
.nodeset v(xcm.n2991901)=152.499998749999
.nodeset v(xcm.n2991905)=2.4999987499995
.nodeset v(xcm.n2991907)=2.4999987499995
.nodeset v(xcm.n2991925)=2.4999987499995
.nodeset v(xcm.n2991931)=2.4999987499995
.nodeset v(xcm.n2991943)=-147.500001250001
.nodeset v(xcm.n2991969)=2.52500879956792
.nodeset v(xcm.n2991997)=4.98488892140372
.nodeset v(xcm.n2992001)=0.0230822480572969
.nodeset v(xcm.n2992029)=0.0230822480572969
.nodeset v(xcm.n2992033)=4.98488892140372
.nodeset v(xcm.n2992093)=2.49999869488949
.nodeset v(xcm.n2992099)=2.4999986948895
.nodeset v(xcm.n2992105)=2.4999987499995
.nodeset v(xcm.n2992151)=2.52499898688423
.nodeset v(xcm.n2992163)=2.52500025215156
.nodeset v(xcm.n2992235)=2.52500025215156
.nodeset v(xcm.n2992267)=-52.4749966887094
.nodeset v(xcm.n2992287)=57.5250032010707
.nodeset v(xcm.n2992295)=-52.4749967438193
.nodeset v(xcm.n2992299)=-52.4749966887094
.nodeset v(xcm.n2992323)=57.5250032010707
.nodeset v(xcm.n2992331)=57.5250032561807
.nodeset v(xcm.n2992375)=2.4999987499995
.nodeset v(xcm.n2992397)=4.99999749749889
.nodeset v(xcm.n2992413)=2.50249884429029e-06
.nodeset v(xcm.n3201092)=3.2132681349299
.nodeset v(xcm.n3294524)=2.52500325618088
.nodeset v(xcm.n3294618)=2.52500325618064
.nodeset v(xcm.n3294626)=3.213268093832
.nodeset v(xcm.n3294630)=2.83965083806159
.nodeset v(xcm.n3294682)=3.21251941909941
.nodeset v(xcm.n3294772)=2.49999875004243
.nodeset v(xcm.n3294776)=2.49999874999962
.nodeset v(xcm.n3827259)=3.21312875387368
.nodeset v(xcm.n3828449)=2.50056879796422
.nodeset v(xcm.n3850714)=2.50025224987021
.nodeset v(xcm.n3850724)=2.499999000028
.nodeset v(xcm.n4031911)=2.52500879956792
.nodeset v(xcm.n4243633)=2.09499936154938
.nodeset v(xcm.n4736080)=2.5465402985421
.nodeset v(xcm.n4745674)=3.2132681349299
.nodeset v(xcm.n4747399)=3.2132681349299
.nodeset v(xcm.n4749239)=3.2132681349299
.nodeset v(xcm.n4796554)=3.2132681349299
.nodeset v(xcm.n4796572)=3.21326813492991
.nodeset v(xcm.n4797748)=3.21321573103711
.nodeset v(xcm.n4797760)=2.68917680301535
.nodeset v(xcm.n4798545)=3.21320000986927
.nodeset v(xcm.n4800105)=3.21320000986927
.nodeset v(xcm.n4809008)=2.49999875004255
.nodeset v(xcm.n4817896)=2.50025227890046
.nodeset v(xcm.n47456861)=3.2132681349299
.nodeset v(xcm.n47492651)=3.2132681349299
.nodeset v(xcm.n47965841)=3.21326813492991
.nodeset v(xcm.n48001371)=3.21320000986927
.nodeset v(xcm.sw_ol_opax388)=2.4999987499995
.nodeset v(xcm.v11)=2.49999869488949
.nodeset v(xcm.v12)=2.4999986948895
.nodeset v(xcm.vcc_b)=4.99999749999889
.nodeset v(xcm.vcc_clp)=4.98488891891883
.nodeset v(xcm.vclp)=2.52500325618065
.nodeset v(xcm.vee_b)=2.49999884804279e-06
.nodeset v(xcm.vee_clp)=0.0230822505342133
.nodeset v(xcm.vimon)=2.52499898688423
.nodeset v(xcm.vout_s)=2.52500025215156
.nodeset v(xcm.vsense)=2.52500879956792
.nodeset v(xcm.x_u4.e1_int1)=-3.00202e-07
.nodeset v(xcm.x_u6.g1_int1)=1.42012250137213e-06
.nodeset v(xcm.x_u10.gvo+_int1)=0
.nodeset v(xcm.x_u10.gvo-_int1)=0
.nodeset v(xcm.x_u11.gvo+_int1)=0
.nodeset v(xcm.x_u11.gvo-_int1)=0
.nodeset v(xcm.x_u12.gvo+_int1)=0
.nodeset v(xcm.x_u12.gvo-_int1)=0
.nodeset v(xcm.x_u16.gsw+_int1)=0
.nodeset v(xcm.x_u18.g1_int1)=1.51085787130519e-05
.nodeset v(xcm.x_u18.g1_int2)=0.0250002368847371
.nodeset v(xcm.x_u19.g1_int1)=2.3079748057903e-05
.nodeset v(xcm.x_u19.g1_int2)=-0.0250002368847371
.nodeset v(xcm.x_u22.g1_int1)=0
.nodeset v(xcm.x_u23.g1_int1)=0
.nodeset v(xcm.x_u26.g1_int1)=2.50002368847369e-05
.nodeset v(xcm.x_u27.g1_int1)=0
.nodeset v(xcm.x_u30.g1_int1)=9.99657713378344e-14
.nodeset v(xcm.x_u31.g1_int1)=2.50100610221793e-08
.nodeset v(xcm.x_u32.g1_int1)=0.712559955910365
.nodeset v(xcm.x_u35.g1_int1)=0
.nodeset v(xcm.x_u38.3)=0
.nodeset v(xcm.x_u38.5)=0
.nodeset v(xcm.x_u39.3)=0
.nodeset v(xcm.x_u39.5)=0
.nodeset v(xcm.x_u40.5)=0
.nodeset v(xex.cl_clamp)=2.24998815208061
.nodeset v(xex.clamp)=2.24993272579741
.nodeset v(xex.claw_clamp)=2.24998815208061
.nodeset v(xex.esdn)=2.24999993888888
.nodeset v(xex.esdp)=2.24999975409615
.nodeset v(xex.mid)=2.4999987499995
.nodeset v(xex.n2991553)=2.49999872499885
.nodeset v(xex.n2991555)=2.24999945389415
.nodeset v(xex.n2991563)=2.24999942872257
.nodeset v(xex.n2991573)=2.24999975409615
.nodeset v(xex.n2991579)=2.49999849987203
.nodeset v(xex.n2991581)=2.49999900005663
.nodeset v(xex.n2991583)=2.24999942872257
.nodeset v(xex.n2991587)=2.24999992890718
.nodeset v(xex.n2991619)=2.24999993888888
.nodeset v(xex.n2991623)=5.0999974999989
.nodeset v(xex.n2991635)=-0.099997500001152
.nodeset v(xex.n2991643)=2.24999992890718
.nodeset v(xex.n2991657)=2.24999992890718
.nodeset v(xex.n2991667)=2.49999775447366
.nodeset v(xex.n2991729)=2.4999987499995
.nodeset v(xex.n2991741)=2.4999987499995
.nodeset v(xex.n2991763)=2.4999987499995
.nodeset v(xex.n2991765)=2.4999987499995
.nodeset v(xex.n2991807)=62.4999987499995
.nodeset v(xex.n2991809)=2.4999987499995
.nodeset v(xex.n2991811)=2.4999987499995
.nodeset v(xex.n2991831)=2.4999987499995
.nodeset v(xex.n2991837)=2.4999987499995
.nodeset v(xex.n2991849)=-57.5000012500005
.nodeset v(xex.n2991901)=152.499998749999
.nodeset v(xex.n2991905)=2.4999987499995
.nodeset v(xex.n2991907)=2.4999987499995
.nodeset v(xex.n2991925)=2.4999987499995
.nodeset v(xex.n2991931)=2.4999987499995
.nodeset v(xex.n2991943)=-147.500001250001
.nodeset v(xex.n2991969)=2.24993272585061
.nodeset v(xex.n2991997)=4.98506425035284
.nodeset v(xex.n2992001)=0.0234412504944267
.nodeset v(xex.n2992029)=0.0234412504944267
.nodeset v(xex.n2992033)=4.98506425035284
.nodeset v(xex.n2992093)=2.49999869488955
.nodeset v(xex.n2992099)=2.49999869488944
.nodeset v(xex.n2992105)=2.4999987499995
.nodeset v(xex.n2992151)=2.49999871591864
.nodeset v(xex.n2992163)=2.24999974616182
.nodeset v(xex.n2992235)=2.24999974616182
.nodeset v(xex.n2992267)=-52.7500117928094
.nodeset v(xex.n2992287)=57.2499880969706
.nodeset v(xex.n2992295)=-52.7500118479194
.nodeset v(xex.n2992299)=-52.7500117928094
.nodeset v(xex.n2992323)=57.2499880969706
.nodeset v(xex.n2992331)=57.2499881520806
.nodeset v(xex.n2992375)=2.4999987499995
.nodeset v(xex.n2992397)=4.9999974974989
.nodeset v(xex.n2992413)=2.50249884429878e-06
.nodeset v(xex.n3201092)=-0.252871793804084
.nodeset v(xex.n3294524)=2.24998815208057
.nodeset v(xex.n3294618)=2.24998815208061
.nodeset v(xex.n3294626)=-0.25287163518632
.nodeset v(xex.n3294630)=1.18910801485493
.nodeset v(xex.n3294682)=-0.249990888577486
.nodeset v(xex.n3294772)=2.49998995253492
.nodeset v(xex.n3294776)=2.49999872499798
.nodeset v(xex.n3827259)=-0.252333851180755
.nodeset v(xex.n3828449)=2.49779864400335
.nodeset v(xex.n3850714)=2.50025224987021
.nodeset v(xex.n3850724)=2.499999000028
.nodeset v(xex.n4031911)=2.24993272585061
.nodeset v(xex.n4243633)=2.09499936154938
.nodeset v(xex.n4736080)=2.03464741313232
.nodeset v(xex.n4745674)=-0.252871793804084
.nodeset v(xex.n4747399)=-0.252871793804084
.nodeset v(xex.n4749239)=-0.252871793804084
.nodeset v(xex.n4796554)=-0.252871793804084
.nodeset v(xex.n4796572)=-0.252871793804085
.nodeset v(xex.n4797748)=-0.252669540439614
.nodeset v(xex.n4797760)=1.76986410426216
.nodeset v(xex.n4798545)=-0.252608864430273
.nodeset v(xex.n4800105)=-0.252608864430273
.nodeset v(xex.n4809008)=2.49998995284204
.nodeset v(xex.n4817896)=2.50025227890046
.nodeset v(xex.n47456861)=-0.252871793804084
.nodeset v(xex.n47492651)=-0.252871793804084
.nodeset v(xex.n47965841)=-0.252871793804085
.nodeset v(xex.n48001371)=-0.252608864430273
.nodeset v(xex.sw_ol_opax388)=2.4999987499995
.nodeset v(xex.v11)=2.49999869488955
.nodeset v(xex.v12)=2.49999869488944
.nodeset v(xex.vcc_b)=4.9999974999989
.nodeset v(xex.vcc_clp)=4.98506424786777
.nodeset v(xex.vclp)=2.24998815208062
.nodeset v(xex.vee_b)=2.49999884805127e-06
.nodeset v(xex.vee_clp)=0.0234412529709842
.nodeset v(xex.vimon)=2.49999871591864
.nodeset v(xex.vout_s)=2.24999974616182
.nodeset v(xex.vsense)=2.24993272585061
.nodeset v(xex.x_u4.e1_int1)=-3.00202e-07
.nodeset v(xex.x_u6.g1_int1)=-0.249998821092318
.nodeset v(xex.x_u10.gvo+_int1)=0
.nodeset v(xex.x_u10.gvo-_int1)=0
.nodeset v(xex.x_u11.gvo+_int1)=0
.nodeset v(xex.x_u11.gvo-_int1)=0
.nodeset v(xex.x_u12.gvo+_int1)=0
.nodeset v(xex.x_u12.gvo-_int1)=0
.nodeset v(xex.x_u16.gsw+_int1)=0
.nodeset v(xex.x_u18.g1_int1)=1.4933249763939e-05
.nodeset v(xex.x_u18.g1_int2)=-3.40808501420042e-08
.nodeset v(xex.x_u19.g1_int1)=2.34387504950244e-05
.nodeset v(xex.x_u19.g1_int2)=3.40808501420042e-08
.nodeset v(xex.x_u22.g1_int1)=0
.nodeset v(xex.x_u23.g1_int1)=0
.nodeset v(xex.x_u26.g1_int1)=0
.nodeset v(xex.x_u27.g1_int1)=3.40808501211876e-11
.nodeset v(xex.x_u30.g1_int1)=-9.98169889842096e-13
.nodeset v(xex.x_u31.g1_int1)=-2.50066135243365e-07
.nodeset v(xex.x_u32.g1_int1)=-2.75013249518406
.nodeset v(xex.x_u35.g1_int1)=0
.nodeset v(xex.x_u38.3)=0
.nodeset v(xex.x_u38.5)=0
.nodeset v(xex.x_u39.3)=0
.nodeset v(xex.x_u39.5)=0
.nodeset v(xex.x_u40.5)=0
.nodeset v(xr0.cl_clamp)=2.50000222759359
.nodeset v(xr0.clamp)=2.50000222830568
.nodeset v(xr0.claw_clamp)=2.50000222759359
.nodeset v(xr0.esdn)=2.50000164001913
.nodeset v(xr0.esdp)=2.50000001521453
.nodeset v(xr0.mid)=2.4999987499995
.nodeset v(xr0.n2991553)=2.49999874999962
.nodeset v(xr0.n2991555)=2.49999534521453
.nodeset v(xr0.n2991563)=2.49999534502473
.nodeset v(xr0.n2991573)=2.50000001521453
.nodeset v(xr0.n2991579)=2.49999560298178
.nodeset v(xr0.n2991581)=2.50000189797161
.nodeset v(xr0.n2991583)=2.49999534502473
.nodeset v(xr0.n2991587)=2.50000164001456
.nodeset v(xr0.n2991619)=2.50000164001913
.nodeset v(xr0.n2991623)=5.0999974999989
.nodeset v(xr0.n2991635)=-0.099997500001152
.nodeset v(xr0.n2991643)=2.50000164001456
.nodeset v(xr0.n2991657)=2.50000164001456
.nodeset v(xr0.n2991667)=2.49999875001334
.nodeset v(xr0.n2991729)=2.4999987499995
.nodeset v(xr0.n2991741)=2.4999987499995
.nodeset v(xr0.n2991763)=2.4999987499995
.nodeset v(xr0.n2991765)=2.4999987499995
.nodeset v(xr0.n2991807)=62.4999987499995
.nodeset v(xr0.n2991809)=2.4999987499995
.nodeset v(xr0.n2991811)=2.4999987499995
.nodeset v(xr0.n2991831)=2.4999987499995
.nodeset v(xr0.n2991837)=2.4999987499995
.nodeset v(xr0.n2991849)=-57.5000012500005
.nodeset v(xr0.n2991901)=152.499998749999
.nodeset v(xr0.n2991905)=2.49999874999964
.nodeset v(xr0.n2991907)=2.49999874999964
.nodeset v(xr0.n2991925)=2.49999874999964
.nodeset v(xr0.n2991931)=2.49999874999964
.nodeset v(xr0.n2991943)=-147.500001250001
.nodeset v(xr0.n2991969)=2.50000222836479
.nodeset v(xr0.n2991997)=4.98506424498325
.nodeset v(xr0.n2992001)=0.023441239234309
.nodeset v(xr0.n2992029)=0.023441239234309
.nodeset v(xr0.n2992033)=4.98506424498325
.nodeset v(xr0.n2992093)=2.49999869488949
.nodeset v(xr0.n2992099)=2.49999869488949
.nodeset v(xr0.n2992105)=2.4999987499995
.nodeset v(xr0.n2992151)=2.49999949114215
.nodeset v(xr0.n2992163)=2.50000222737764
.nodeset v(xr0.n2992235)=2.50000222737764
.nodeset v(xr0.n2992267)=-52.4999977172964
.nodeset v(xr0.n2992287)=57.5000021724836
.nodeset v(xr0.n2992295)=-52.4999977724064
.nodeset v(xr0.n2992299)=-52.4999977172964
.nodeset v(xr0.n2992323)=57.5000021724836
.nodeset v(xr0.n2992331)=57.5000022275936
.nodeset v(xr0.n2992375)=2.4999987499995
.nodeset v(xr0.n2992397)=4.9999974974989
.nodeset v(xr0.n2992413)=2.50249884429878e-06
.nodeset v(xr0.n3201092)=2.50005002501453
.nodeset v(xr0.n3294524)=2.50000222759382
.nodeset v(xr0.n3294618)=2.50000222759359
.nodeset v(xr0.n3294626)=2.50005002501158
.nodeset v(xr0.n3294630)=2.50002316667332
.nodeset v(xr0.n3294682)=2.50004997128735
.nodeset v(xr0.n3294772)=2.49999875004402
.nodeset v(xr0.n3294776)=2.49999874999962
.nodeset v(xr0.n3827259)=2.50005001499482
.nodeset v(xr0.n3828449)=2.49999879097871
.nodeset v(xr0.n3850714)=2.50103724946989
.nodeset v(xr0.n3850724)=2.50000189746958
.nodeset v(xr0.n4031911)=2.50000222836479
.nodeset v(xr0.n4243633)=1.1860007341391
.nodeset v(xr0.n4736080)=2.50000522293778
.nodeset v(xr0.n4745674)=2.50005002501453
.nodeset v(xr0.n4747399)=2.50005002501453
.nodeset v(xr0.n4749239)=2.50005002501454
.nodeset v(xr0.n4796554)=2.50005002501454
.nodeset v(xr0.n4796572)=2.50005002501454
.nodeset v(xr0.n4797748)=2.50005002124737
.nodeset v(xr0.n4797760)=2.50001234950022
.nodeset v(xr0.n4798545)=2.50005002011721
.nodeset v(xr0.n4800105)=2.50005002011722
.nodeset v(xr0.n4809008)=2.49999875004403
.nodeset v(xr0.n4817896)=2.50103741511577
.nodeset v(xr0.n47456861)=2.50005002501453
.nodeset v(xr0.n47492651)=2.50005002501454
.nodeset v(xr0.n47965841)=2.50005002501454
.nodeset v(xr0.n48001371)=2.50005002011722
.nodeset v(xr0.sw_ol_opa4388)=2.4999987499995
.nodeset v(xr0.v11)=2.49999869488949
.nodeset v(xr0.v12)=2.49999869488949
.nodeset v(xr0.vcc_b)=4.9999974999989
.nodeset v(xr0.vcc_clp)=4.98506424249818
.nodeset v(xr0.vclp)=2.5000022275936
.nodeset v(xr0.vee_b)=2.49999884805127e-06
.nodeset v(xr0.vee_clp)=0.0234412417108665
.nodeset v(xr0.vimon)=2.49999949114215
.nodeset v(xr0.vout_s)=2.50000222737764
.nodeset v(xr0.vsense)=2.50000222836479
.nodeset v(xr0.x_u4.e1_int1)=-4.67e-06
.nodeset v(xr0.x_u6.g1_int1)=2.89001506814657e-06
.nodeset v(xr0.x_u10.gvo+_int1)=0
.nodeset v(xr0.x_u10.gvo-_int1)=0
.nodeset v(xr0.x_u11.gvo+_int1)=0
.nodeset v(xr0.x_u11.gvo-_int1)=0
.nodeset v(xr0.x_u12.gvo+_int1)=0
.nodeset v(xr0.x_u12.gvo-_int1)=0
.nodeset v(xr0.x_u16.gsw+_int1)=0
.nodeset v(xr0.x_u18.g1_int1)=1.49332551335265e-05
.nodeset v(xr0.x_u18.g1_int2)=7.4114265125047e-07
.nodeset v(xr0.x_u19.g1_int1)=2.34387392349066e-05
.nodeset v(xr0.x_u19.g1_int2)=-7.4114265125047e-07
.nodeset v(xr0.x_u22.g1_int1)=0
.nodeset v(xr0.x_u23.g1_int1)=0
.nodeset v(xr0.x_u26.g1_int1)=7.41142651156795e-10
.nodeset v(xr0.x_u27.g1_int1)=0
.nodeset v(xr0.x_u30.g1_int1)=-4.56882795485392e-16
.nodeset v(xr0.x_u31.g1_int1)=3.47832873615062e-12
.nodeset v(xr0.x_u32.g1_int1)=5.12240162606759e-05
.nodeset v(xr0.x_u35.g1_int1)=0
.nodeset v(xr0.x_u38.3)=0
.nodeset v(xr0.x_u38.5)=0
.nodeset v(xr0.x_u39.3)=0
.nodeset v(xr0.x_u39.5)=0
.nodeset v(xr0.x_u40.5)=0
.nodeset v(xr1.cl_clamp)=2.50000222736109
.nodeset v(xr1.clamp)=2.50000222807284
.nodeset v(xr1.claw_clamp)=2.50000222736109
.nodeset v(xr1.esdn)=2.50000163999034
.nodeset v(xr1.esdp)=2.50000001521462
.nodeset v(xr1.mid)=2.4999987499995
.nodeset v(xr1.n2991553)=2.49999874999962
.nodeset v(xr1.n2991555)=2.49999534521462
.nodeset v(xr1.n2991563)=2.49999534502483
.nodeset v(xr1.n2991573)=2.50000001521462
.nodeset v(xr1.n2991579)=2.49999560298178
.nodeset v(xr1.n2991581)=2.50000189797161
.nodeset v(xr1.n2991583)=2.49999534502483
.nodeset v(xr1.n2991587)=2.50000164001466
.nodeset v(xr1.n2991619)=2.50000163999034
.nodeset v(xr1.n2991623)=5.0999974999989
.nodeset v(xr1.n2991635)=-0.099997500001152
.nodeset v(xr1.n2991643)=2.50000164001466
.nodeset v(xr1.n2991657)=2.50000164001466
.nodeset v(xr1.n2991667)=2.49999875001334
.nodeset v(xr1.n2991729)=2.4999987499995
.nodeset v(xr1.n2991741)=2.4999987499995
.nodeset v(xr1.n2991763)=2.4999987499995
.nodeset v(xr1.n2991765)=2.4999987499995
.nodeset v(xr1.n2991807)=62.4999987499995
.nodeset v(xr1.n2991809)=2.4999987499995
.nodeset v(xr1.n2991811)=2.4999987499995
.nodeset v(xr1.n2991831)=2.4999987499995
.nodeset v(xr1.n2991837)=2.4999987499995
.nodeset v(xr1.n2991849)=-57.5000012500005
.nodeset v(xr1.n2991901)=152.499998749999
.nodeset v(xr1.n2991905)=2.4999987499995
.nodeset v(xr1.n2991907)=2.4999987499995
.nodeset v(xr1.n2991925)=2.4999987499995
.nodeset v(xr1.n2991931)=2.4999987499995
.nodeset v(xr1.n2991943)=-147.500001250001
.nodeset v(xr1.n2991969)=2.50000222813196
.nodeset v(xr1.n2991997)=4.98506424498466
.nodeset v(xr1.n2992001)=0.0234412392372675
.nodeset v(xr1.n2992029)=0.0234412392372675
.nodeset v(xr1.n2992033)=4.98506424498466
.nodeset v(xr1.n2992093)=2.4999986948895
.nodeset v(xr1.n2992099)=2.49999869488949
.nodeset v(xr1.n2992105)=2.4999987499995
.nodeset v(xr1.n2992151)=2.49999949093846
.nodeset v(xr1.n2992163)=2.50000222714516
.nodeset v(xr1.n2992235)=2.50000222714516
.nodeset v(xr1.n2992267)=-52.4999977175289
.nodeset v(xr1.n2992287)=57.5000021722511
.nodeset v(xr1.n2992295)=-52.4999977726389
.nodeset v(xr1.n2992299)=-52.4999977175289
.nodeset v(xr1.n2992323)=57.5000021722511
.nodeset v(xr1.n2992331)=57.5000022273611
.nodeset v(xr1.n2992375)=2.4999987499995
.nodeset v(xr1.n2992397)=4.9999974974989
.nodeset v(xr1.n2992413)=2.50249884429878e-06
.nodeset v(xr1.n3201092)=2.5000500187281
.nodeset v(xr1.n3294524)=2.50000222736105
.nodeset v(xr1.n3294618)=2.50000222736109
.nodeset v(xr1.n3294626)=2.50005001872515
.nodeset v(xr1.n3294630)=2.50002316367978
.nodeset v(xr1.n3294682)=2.50004996500729
.nodeset v(xr1.n3294772)=2.49999875004402
.nodeset v(xr1.n3294776)=2.49999874999962
.nodeset v(xr1.n3827259)=2.50005000870961
.nodeset v(xr1.n3828449)=2.49999879097368
.nodeset v(xr1.n3850714)=2.50103724946989
.nodeset v(xr1.n3850724)=2.50000189746958
.nodeset v(xr1.n4031911)=2.50000222813196
.nodeset v(xr1.n4243633)=1.1860007341391
.nodeset v(xr1.n4736080)=2.5000052225045
.nodeset v(xr1.n4745674)=2.5000500187281
.nodeset v(xr1.n4747399)=2.5000500187281
.nodeset v(xr1.n4749239)=2.50005001872811
.nodeset v(xr1.n4796554)=2.50005001872811
.nodeset v(xr1.n4796572)=2.50005001872811
.nodeset v(xr1.n4797748)=2.5000500149614
.nodeset v(xr1.n4797760)=2.50001234783289
.nodeset v(xr1.n4798545)=2.50005001383139
.nodeset v(xr1.n4800105)=2.50005001383139
.nodeset v(xr1.n4809008)=2.49999875004403
.nodeset v(xr1.n4817896)=2.50103741511577
.nodeset v(xr1.n47456861)=2.5000500187281
.nodeset v(xr1.n47492651)=2.50005001872811
.nodeset v(xr1.n47965841)=2.50005001872811
.nodeset v(xr1.n48001371)=2.50005001383139
.nodeset v(xr1.sw_ol_opa4388)=2.4999987499995
.nodeset v(xr1.v11)=2.4999986948895
.nodeset v(xr1.v12)=2.49999869488949
.nodeset v(xr1.vcc_b)=4.9999974999989
.nodeset v(xr1.vcc_clp)=4.9850642424996
.nodeset v(xr1.vclp)=2.50000222736109
.nodeset v(xr1.vee_b)=2.49999884805127e-06
.nodeset v(xr1.vee_clp)=0.023441241713825
.nodeset v(xr1.vimon)=2.49999949093846
.nodeset v(xr1.vout_s)=2.50000222714516
.nodeset v(xr1.vsense)=2.50000222813196
.nodeset v(xr1.x_u4.e1_int1)=-4.67e-06
.nodeset v(xr1.x_u6.g1_int1)=2.89001516229348e-06
.nodeset v(xr1.x_u10.gvo+_int1)=0
.nodeset v(xr1.x_u10.gvo-_int1)=0
.nodeset v(xr1.x_u11.gvo+_int1)=0
.nodeset v(xr1.x_u11.gvo-_int1)=0
.nodeset v(xr1.x_u12.gvo+_int1)=0
.nodeset v(xr1.x_u12.gvo-_int1)=0
.nodeset v(xr1.x_u16.gsw+_int1)=0
.nodeset v(xr1.x_u18.g1_int1)=1.49332551321156e-05
.nodeset v(xr1.x_u18.g1_int2)=7.40938964405302e-07
.nodeset v(xr1.x_u19.g1_int1)=2.34387392378652e-05
.nodeset v(xr1.x_u19.g1_int2)=-7.40938964405302e-07
.nodeset v(xr1.x_u22.g1_int1)=0
.nodeset v(xr1.x_u23.g1_int1)=0
.nodeset v(xr1.x_u26.g1_int1)=7.40938964263055e-10
.nodeset v(xr1.x_u27.g1_int1)=0
.nodeset v(xr1.x_u30.g1_int1)=2.43132337179874e-15
.nodeset v(xr1.x_u31.g1_int1)=3.47843975845308e-12
.nodeset v(xr1.x_u32.g1_int1)=5.12177361997601e-05
.nodeset v(xr1.x_u35.g1_int1)=0
.nodeset v(xr1.x_u38.3)=0
.nodeset v(xr1.x_u38.5)=0
.nodeset v(xr1.x_u39.3)=0
.nodeset v(xr1.x_u39.5)=0
.nodeset v(xr1.x_u40.5)=0
.nodeset v(xr2.cl_clamp)=2.50000222899054
.nodeset v(xr2.clamp)=2.50000222970266
.nodeset v(xr2.claw_clamp)=2.50000222899054
.nodeset v(xr2.esdn)=2.50000164025258
.nodeset v(xr2.esdp)=2.50000001521565
.nodeset v(xr2.mid)=2.4999987499995
.nodeset v(xr2.n2991553)=2.49999874999962
.nodeset v(xr2.n2991555)=2.49999534521565
.nodeset v(xr2.n2991563)=2.4999953452749
.nodeset v(xr2.n2991573)=2.50000001521565
.nodeset v(xr2.n2991579)=2.49999560298179
.nodeset v(xr2.n2991581)=2.50000189797161
.nodeset v(xr2.n2991583)=2.4999953452749
.nodeset v(xr2.n2991587)=2.50000164026473
.nodeset v(xr2.n2991619)=2.50000164025258
.nodeset v(xr2.n2991623)=5.0999974999989
.nodeset v(xr2.n2991635)=-0.099997500001152
.nodeset v(xr2.n2991643)=2.50000164026473
.nodeset v(xr2.n2991657)=2.50000164026473
.nodeset v(xr2.n2991667)=2.49999875001335
.nodeset v(xr2.n2991729)=2.4999987499995
.nodeset v(xr2.n2991741)=2.4999987499995
.nodeset v(xr2.n2991763)=2.4999987499995
.nodeset v(xr2.n2991765)=2.4999987499995
.nodeset v(xr2.n2991807)=62.4999987499995
.nodeset v(xr2.n2991809)=2.4999987499995
.nodeset v(xr2.n2991811)=2.4999987499995
.nodeset v(xr2.n2991831)=2.4999987499995
.nodeset v(xr2.n2991837)=2.4999987499995
.nodeset v(xr2.n2991849)=-57.5000012500005
.nodeset v(xr2.n2991901)=152.499998749999
.nodeset v(xr2.n2991905)=2.4999987499995
.nodeset v(xr2.n2991907)=2.4999987499995
.nodeset v(xr2.n2991925)=2.4999987499995
.nodeset v(xr2.n2991931)=2.4999987499995
.nodeset v(xr2.n2991943)=-147.500001250001
.nodeset v(xr2.n2991969)=2.50000222976178
.nodeset v(xr2.n2991997)=4.98506424497519
.nodeset v(xr2.n2992001)=0.0234412392174115
.nodeset v(xr2.n2992029)=0.0234412392174115
.nodeset v(xr2.n2992033)=4.98506424497519
.nodeset v(xr2.n2992093)=2.4999986948895
.nodeset v(xr2.n2992099)=2.49999869488949
.nodeset v(xr2.n2992105)=2.4999987499995
.nodeset v(xr2.n2992151)=2.49999949230549
.nodeset v(xr2.n2992163)=2.50000222877444
.nodeset v(xr2.n2992235)=2.50000222877444
.nodeset v(xr2.n2992267)=-52.4999977158994
.nodeset v(xr2.n2992287)=57.5000021738806
.nodeset v(xr2.n2992295)=-52.4999977710094
.nodeset v(xr2.n2992299)=-52.4999977158994
.nodeset v(xr2.n2992323)=57.5000021738806
.nodeset v(xr2.n2992331)=57.5000022289906
.nodeset v(xr2.n2992375)=2.4999987499995
.nodeset v(xr2.n2992397)=4.9999974974989
.nodeset v(xr2.n2992413)=2.50249884429877e-06
.nodeset v(xr2.n3201092)=2.50005006063762
.nodeset v(xr2.n3294524)=2.5000022289905
.nodeset v(xr2.n3294618)=2.50000222899054
.nodeset v(xr2.n3294626)=2.50005006063467
.nodeset v(xr2.n3294630)=2.5000231836367
.nodeset v(xr2.n3294682)=2.50005000687315
.nodeset v(xr2.n3294772)=2.49999875004402
.nodeset v(xr2.n3294776)=2.49999874999962
.nodeset v(xr2.n3827259)=2.50005005061094
.nodeset v(xr2.n3828449)=2.49999879100718
.nodeset v(xr2.n3850714)=2.50103724946989
.nodeset v(xr2.n3850724)=2.50000189746958
.nodeset v(xr2.n4031911)=2.50000222976178
.nodeset v(xr2.n4243633)=1.1860007341391
.nodeset v(xr2.n4736080)=2.50000522553744
.nodeset v(xr2.n4745674)=2.50005006063762
.nodeset v(xr2.n4747399)=2.50005006063762
.nodeset v(xr2.n4749239)=2.50005006063762
.nodeset v(xr2.n4796554)=2.50005006063762
.nodeset v(xr2.n4796572)=2.50005006063763
.nodeset v(xr2.n4797748)=2.50005005686784
.nodeset v(xr2.n4797760)=2.50001235894841
.nodeset v(xr2.n4798545)=2.5000500557369
.nodeset v(xr2.n4800105)=2.5000500557369
.nodeset v(xr2.n4809008)=2.49999875004414
.nodeset v(xr2.n4817896)=2.50103741511577
.nodeset v(xr2.n47456861)=2.50005006063762
.nodeset v(xr2.n47492651)=2.50005006063762
.nodeset v(xr2.n47965841)=2.50005006063763
.nodeset v(xr2.n48001371)=2.5000500557369
.nodeset v(xr2.sw_ol_opa4388)=2.4999987499995
.nodeset v(xr2.v11)=2.4999986948895
.nodeset v(xr2.v12)=2.49999869488949
.nodeset v(xr2.vcc_b)=4.9999974999989
.nodeset v(xr2.vcc_clp)=4.98506424249013
.nodeset v(xr2.vclp)=2.50000222899055
.nodeset v(xr2.vee_b)=2.49999884805127e-06
.nodeset v(xr2.vee_clp)=0.0234412416939689
.nodeset v(xr2.vimon)=2.49999949230549
.nodeset v(xr2.vout_s)=2.50000222877444
.nodeset v(xr2.vsense)=2.50000222976178
.nodeset v(xr2.x_u4.e1_int1)=-4.67e-06
.nodeset v(xr2.x_u6.g1_int1)=2.89026522981572e-06
.nodeset v(xr2.x_u10.gvo+_int1)=0
.nodeset v(xr2.x_u10.gvo-_int1)=0
.nodeset v(xr2.x_u11.gvo+_int1)=0
.nodeset v(xr2.x_u11.gvo-_int1)=0
.nodeset v(xr2.x_u12.gvo+_int1)=0
.nodeset v(xr2.x_u12.gvo-_int1)=0
.nodeset v(xr2.x_u16.gsw+_int1)=0
.nodeset v(xr2.x_u18.g1_int1)=1.49332551415844e-05
.nodeset v(xr2.x_u18.g1_int2)=7.42305992673664e-07
.nodeset v(xr2.x_u19.g1_int1)=2.34387392180091e-05
.nodeset v(xr2.x_u19.g1_int2)=-7.42305992673664e-07
.nodeset v(xr2.x_u22.g1_int1)=0
.nodeset v(xr2.x_u23.g1_int1)=0
.nodeset v(xr2.x_u26.g1_int1)=7.42305992715298e-10
.nodeset v(xr2.x_u27.g1_int1)=0
.nodeset v(xr2.x_u30.g1_int1)=1.21463169383551e-15
.nodeset v(xr2.x_u31.g1_int1)=3.47977202608263e-12
.nodeset v(xr2.x_u32.g1_int1)=5.12596043336089e-05
.nodeset v(xr2.x_u35.g1_int1)=0
.nodeset v(xr2.x_u38.3)=0
.nodeset v(xr2.x_u38.5)=0
.nodeset v(xr2.x_u39.3)=0
.nodeset v(xr2.x_u39.5)=0
.nodeset v(xr2.x_u40.5)=0
.nodeset v(xr3.cl_clamp)=2.50000222736109
.nodeset v(xr3.clamp)=2.50000222807284
.nodeset v(xr3.claw_clamp)=2.50000222736109
.nodeset v(xr3.esdn)=2.50000163999097
.nodeset v(xr3.esdp)=2.50000001521453
.nodeset v(xr3.mid)=2.4999987499995
.nodeset v(xr3.n2991553)=2.49999874999962
.nodeset v(xr3.n2991555)=2.49999534521453
.nodeset v(xr3.n2991563)=2.49999534502474
.nodeset v(xr3.n2991573)=2.50000001521453
.nodeset v(xr3.n2991579)=2.49999560298178
.nodeset v(xr3.n2991581)=2.50000189797161
.nodeset v(xr3.n2991583)=2.49999534502474
.nodeset v(xr3.n2991587)=2.50000164001457
.nodeset v(xr3.n2991619)=2.50000163999097
.nodeset v(xr3.n2991623)=5.0999974999989
.nodeset v(xr3.n2991635)=-0.099997500001152
.nodeset v(xr3.n2991643)=2.50000164001457
.nodeset v(xr3.n2991657)=2.50000164001457
.nodeset v(xr3.n2991667)=2.49999875001334
.nodeset v(xr3.n2991729)=2.4999987499995
.nodeset v(xr3.n2991741)=2.4999987499995
.nodeset v(xr3.n2991763)=2.4999987499995
.nodeset v(xr3.n2991765)=2.4999987499995
.nodeset v(xr3.n2991807)=62.4999987499995
.nodeset v(xr3.n2991809)=2.4999987499995
.nodeset v(xr3.n2991811)=2.4999987499995
.nodeset v(xr3.n2991831)=2.4999987499995
.nodeset v(xr3.n2991837)=2.4999987499995
.nodeset v(xr3.n2991849)=-57.5000012500005
.nodeset v(xr3.n2991901)=152.499998749999
.nodeset v(xr3.n2991905)=2.4999987499995
.nodeset v(xr3.n2991907)=2.4999987499995
.nodeset v(xr3.n2991925)=2.4999987499995
.nodeset v(xr3.n2991931)=2.4999987499995
.nodeset v(xr3.n2991943)=-147.500001250001
.nodeset v(xr3.n2991969)=2.50000222813196
.nodeset v(xr3.n2991997)=4.98506424498467
.nodeset v(xr3.n2992001)=0.0234412392372766
.nodeset v(xr3.n2992029)=0.0234412392372766
.nodeset v(xr3.n2992033)=4.98506424498467
.nodeset v(xr3.n2992093)=2.4999986948895
.nodeset v(xr3.n2992099)=2.49999869488949
.nodeset v(xr3.n2992105)=2.4999987499995
.nodeset v(xr3.n2992151)=2.49999949093783
.nodeset v(xr3.n2992163)=2.50000222714516
.nodeset v(xr3.n2992235)=2.50000222714516
.nodeset v(xr3.n2992267)=-52.4999977175289
.nodeset v(xr3.n2992287)=57.5000021722511
.nodeset v(xr3.n2992295)=-52.4999977726389
.nodeset v(xr3.n2992299)=-52.4999977175289
.nodeset v(xr3.n2992323)=57.5000021722511
.nodeset v(xr3.n2992331)=57.5000022273611
.nodeset v(xr3.n2992375)=2.4999987499995
.nodeset v(xr3.n2992397)=4.9999974974989
.nodeset v(xr3.n2992413)=2.50249884429878e-06
.nodeset v(xr3.n3201092)=2.50005001872811
.nodeset v(xr3.n3294524)=2.50000222736105
.nodeset v(xr3.n3294618)=2.50000222736109
.nodeset v(xr3.n3294626)=2.50005001872515
.nodeset v(xr3.n3294630)=2.50002316367978
.nodeset v(xr3.n3294682)=2.50004996500729
.nodeset v(xr3.n3294772)=2.49999875004402
.nodeset v(xr3.n3294776)=2.49999874999962
.nodeset v(xr3.n3827259)=2.50005000870961
.nodeset v(xr3.n3828449)=2.49999879097368
.nodeset v(xr3.n3850714)=2.50103724946989
.nodeset v(xr3.n3850724)=2.50000189746958
.nodeset v(xr3.n4031911)=2.50000222813196
.nodeset v(xr3.n4243633)=1.1860007341391
.nodeset v(xr3.n4736080)=2.5000052225045
.nodeset v(xr3.n4745674)=2.5000500187281
.nodeset v(xr3.n4747399)=2.5000500187281
.nodeset v(xr3.n4749239)=2.5000500187281
.nodeset v(xr3.n4796554)=2.5000500187281
.nodeset v(xr3.n4796572)=2.50005001872811
.nodeset v(xr3.n4797748)=2.5000500149614
.nodeset v(xr3.n4797760)=2.50001234783289
.nodeset v(xr3.n4798545)=2.50005001383138
.nodeset v(xr3.n4800105)=2.50005001383138
.nodeset v(xr3.n4809008)=2.49999875004403
.nodeset v(xr3.n4817896)=2.50103741511577
.nodeset v(xr3.n47456861)=2.5000500187281
.nodeset v(xr3.n47492651)=2.5000500187281
.nodeset v(xr3.n47965841)=2.50005001872811
.nodeset v(xr3.n48001371)=2.50005001383138
.nodeset v(xr3.sw_ol_opa4388)=2.4999987499995
.nodeset v(xr3.v11)=2.4999986948895
.nodeset v(xr3.v12)=2.49999869488949
.nodeset v(xr3.vcc_b)=4.9999974999989
.nodeset v(xr3.vcc_clp)=4.9850642424996
.nodeset v(xr3.vclp)=2.50000222736109
.nodeset v(xr3.vee_b)=2.49999884805128e-06
.nodeset v(xr3.vee_clp)=0.0234412417138341
.nodeset v(xr3.vimon)=2.49999949093783
.nodeset v(xr3.vout_s)=2.50000222714516
.nodeset v(xr3.vsense)=2.50000222813196
.nodeset v(xr3.x_u4.e1_int1)=-4.67e-06
.nodeset v(xr3.x_u6.g1_int1)=2.89001507347564e-06
.nodeset v(xr3.x_u10.gvo+_int1)=0
.nodeset v(xr3.x_u10.gvo-_int1)=0
.nodeset v(xr3.x_u11.gvo+_int1)=0
.nodeset v(xr3.x_u11.gvo-_int1)=0
.nodeset v(xr3.x_u12.gvo+_int1)=0
.nodeset v(xr3.x_u12.gvo-_int1)=0
.nodeset v(xr3.x_u16.gsw+_int1)=0
.nodeset v(xr3.x_u18.g1_int1)=1.49332551321113e-05
.nodeset v(xr3.x_u18.g1_int2)=7.40938336907249e-07
.nodeset v(xr3.x_u19.g1_int1)=2.34387392378743e-05
.nodeset v(xr3.x_u19.g1_int2)=-7.40938336907249e-07
.nodeset v(xr3.x_u22.g1_int1)=0
.nodeset v(xr3.x_u23.g1_int1)=0
.nodeset v(xr3.x_u26.g1_int1)=7.40938336726837e-10
.nodeset v(xr3.x_u27.g1_int1)=0
.nodeset v(xr3.x_u30.g1_int1)=2.35971181830608e-15
.nodeset v(xr3.x_u31.g1_int1)=3.47843975845308e-12
.nodeset v(xr3.x_u32.g1_int1)=5.12177361997601e-05
.nodeset v(xr3.x_u35.g1_int1)=0
.nodeset v(xr3.x_u38.3)=0
.nodeset v(xr3.x_u38.5)=0
.nodeset v(xr3.x_u39.3)=0
.nodeset v(xr3.x_u39.5)=0
.nodeset v(xr3.x_u40.5)=0
.nodeset v(xt0.cl_clamp)=2.50249656761847
.nodeset v(xt0.clamp)=2.50249712145887
.nodeset v(xt0.claw_clamp)=2.50249656761847
.nodeset v(xt0.esdn)=2.50000164006347
.nodeset v(xt0.esdp)=2.50000001536652
.nodeset v(xt0.mid)=2.4999987499995
.nodeset v(xt0.n2991553)=2.49999874999962
.nodeset v(xt0.n2991555)=2.49999534536652
.nodeset v(xt0.n2991563)=2.49999534517673
.nodeset v(xt0.n2991573)=2.50000001536652
.nodeset v(xt0.n2991579)=2.49999560298179
.nodeset v(xt0.n2991581)=2.50000189797161
.nodeset v(xt0.n2991583)=2.49999534517673
.nodeset v(xt0.n2991587)=2.50000164016656
.nodeset v(xt0.n2991619)=2.50000164006347
.nodeset v(xt0.n2991623)=5.09999749999889
.nodeset v(xt0.n2991635)=-0.099997500001152
.nodeset v(xt0.n2991643)=2.50000164016656
.nodeset v(xt0.n2991657)=2.50000164016656
.nodeset v(xt0.n2991667)=2.49999875994564
.nodeset v(xt0.n2991729)=2.49999874999964
.nodeset v(xt0.n2991741)=2.49999874999964
.nodeset v(xt0.n2991763)=2.4999987499995
.nodeset v(xt0.n2991765)=2.4999987499995
.nodeset v(xt0.n2991807)=62.4999987499995
.nodeset v(xt0.n2991809)=2.4999987499995
.nodeset v(xt0.n2991811)=2.4999987499995
.nodeset v(xt0.n2991831)=2.4999987499995
.nodeset v(xt0.n2991837)=2.4999987499995
.nodeset v(xt0.n2991849)=-57.5000012500005
.nodeset v(xt0.n2991901)=152.499998749999
.nodeset v(xt0.n2991905)=2.4999987499995
.nodeset v(xt0.n2991907)=2.4999987499995
.nodeset v(xt0.n2991925)=2.4999987499995
.nodeset v(xt0.n2991931)=2.4999987499995
.nodeset v(xt0.n2991943)=-147.500001250001
.nodeset v(xt0.n2991969)=2.50249712151805
.nodeset v(xt0.n2991997)=4.98504691955367
.nodeset v(xt0.n2992001)=0.0234049940661909
.nodeset v(xt0.n2992029)=0.0234049940661909
.nodeset v(xt0.n2992033)=4.98504691955367
.nodeset v(xt0.n2992093)=2.4999986948895
.nodeset v(xt0.n2992099)=2.4999986948895
.nodeset v(xt0.n2992105)=2.4999987499995
.nodeset v(xt0.n2992151)=2.50249769406591
.nodeset v(xt0.n2992163)=2.50249626741732
.nodeset v(xt0.n2992235)=2.50249626741732
.nodeset v(xt0.n2992267)=-52.4975033772715
.nodeset v(xt0.n2992287)=57.5024965125085
.nodeset v(xt0.n2992295)=-52.4975034323815
.nodeset v(xt0.n2992299)=-52.4975033772715
.nodeset v(xt0.n2992323)=57.5024965125085
.nodeset v(xt0.n2992331)=57.5024965676185
.nodeset v(xt0.n2992375)=2.4999987499995
.nodeset v(xt0.n2992397)=4.9999974974989
.nodeset v(xt0.n2992413)=2.50249884429792e-06
.nodeset v(xt0.n3201092)=2.57127778405051
.nodeset v(xt0.n3294524)=2.50249656776304
.nodeset v(xt0.n3294618)=2.50249656761847
.nodeset v(xt0.n3294626)=2.57127777994348
.nodeset v(xt0.n3294630)=2.53394114716664
.nodeset v(xt0.n3294682)=2.5712029626975
.nodeset v(xt0.n3294772)=2.49999875004403
.nodeset v(xt0.n3294776)=2.49999874999962
.nodeset v(xt0.n3827259)=2.57126385530597
.nodeset v(xt0.n3828449)=2.50005571651053
.nodeset v(xt0.n3850714)=2.50103724946989
.nodeset v(xt0.n3850724)=2.50000189746958
.nodeset v(xt0.n4031911)=2.50249712151805
.nodeset v(xt0.n4243633)=1.18600073413911
.nodeset v(xt0.n4736080)=2.50464800425187
.nodeset v(xt0.n4745674)=2.5712777840505
.nodeset v(xt0.n4747399)=2.5712777840505
.nodeset v(xt0.n4749239)=2.5712777840505
.nodeset v(xt0.n4796554)=2.5712777840505
.nodeset v(xt0.n4796572)=2.57127778405051
.nodeset v(xt0.n4797748)=2.57127254718077
.nodeset v(xt0.n4797760)=2.51890384976617
.nodeset v(xt0.n4798545)=2.57127097611985
.nodeset v(xt0.n4800105)=2.57127097611985
.nodeset v(xt0.n4809008)=2.49999875004403
.nodeset v(xt0.n4817896)=2.50103741511577
.nodeset v(xt0.n47456861)=2.5712777840505
.nodeset v(xt0.n47492651)=2.5712777840505
.nodeset v(xt0.n47965841)=2.57127778405051
.nodeset v(xt0.n48001371)=2.57127097611985
.nodeset v(xt0.sw_ol_opa4388)=2.4999987499995
.nodeset v(xt0.v11)=2.4999986948895
.nodeset v(xt0.v12)=2.4999986948895
.nodeset v(xt0.vcc_b)=4.9999974999989
.nodeset v(xt0.vcc_clp)=4.98504691706862
.nodeset v(xt0.vclp)=2.50249656761848
.nodeset v(xt0.vee_b)=2.49999884805042e-06
.nodeset v(xt0.vee_clp)=0.0234049965427846
.nodeset v(xt0.vimon)=2.50249769406591
.nodeset v(xt0.vout_s)=2.50249626741732
.nodeset v(xt0.vsense)=2.50249712151805
.nodeset v(xt0.x_u4.e1_int1)=-4.67e-06
.nodeset v(xt0.x_u6.g1_int1)=2.89016705989909e-06
.nodeset v(xt0.x_u10.gvo+_int1)=0
.nodeset v(xt0.x_u10.gvo-_int1)=0
.nodeset v(xt0.x_u11.gvo+_int1)=0
.nodeset v(xt0.x_u11.gvo-_int1)=0
.nodeset v(xt0.x_u12.gvo+_int1)=0
.nodeset v(xt0.x_u12.gvo-_int1)=0
.nodeset v(xt0.x_u16.gsw+_int1)=0
.nodeset v(xt0.x_u18.g1_int1)=1.49505805631076e-05
.nodeset v(xt0.x_u18.g1_int2)=0.00249894406641804
.nodeset v(xt0.x_u19.g1_int1)=2.34024940667894e-05
.nodeset v(xt0.x_u19.g1_int2)=-0.00249894406641804
.nodeset v(xt0.x_u22.g1_int1)=0
.nodeset v(xt0.x_u23.g1_int1)=0
.nodeset v(xt0.x_u26.g1_int1)=2.49894406641801e-06
.nodeset v(xt0.x_u27.g1_int1)=0
.nodeset v(xt0.x_u30.g1_int1)=1.03088110964267e-14
.nodeset v(xt0.x_u31.g1_int1)=2.49837261989683e-09
.nodeset v(xt0.x_u32.g1_int1)=0.071208138795555
.nodeset v(xt0.x_u35.g1_int1)=1.4432899320127e-13
.nodeset v(xt0.x_u38.3)=0
.nodeset v(xt0.x_u38.5)=0
.nodeset v(xt0.x_u39.3)=0
.nodeset v(xt0.x_u39.5)=0
.nodeset v(xt0.x_u40.5)=0
.nodeset v(xt1.cl_clamp)=2.50249657532812
.nodeset v(xt1.clamp)=2.50249712902587
.nodeset v(xt1.claw_clamp)=2.50249657518379
.nodeset v(xt1.esdn)=2.50000164031083
.nodeset v(xt1.esdp)=2.50000001536652
.nodeset v(xt1.mid)=2.4999987499995
.nodeset v(xt1.n2991553)=2.49999874999962
.nodeset v(xt1.n2991555)=2.49999534536652
.nodeset v(xt1.n2991563)=2.49999534542577
.nodeset v(xt1.n2991573)=2.50000001536652
.nodeset v(xt1.n2991579)=2.49999560298179
.nodeset v(xt1.n2991581)=2.50000189797161
.nodeset v(xt1.n2991583)=2.49999534542577
.nodeset v(xt1.n2991587)=2.5000016404156
.nodeset v(xt1.n2991619)=2.50000164031083
.nodeset v(xt1.n2991623)=5.0999974999989
.nodeset v(xt1.n2991635)=-0.099997500001152
.nodeset v(xt1.n2991643)=2.5000016404156
.nodeset v(xt1.n2991657)=2.5000016404156
.nodeset v(xt1.n2991667)=2.49999875994567
.nodeset v(xt1.n2991729)=2.49999874999964
.nodeset v(xt1.n2991741)=2.49999874999964
.nodeset v(xt1.n2991763)=2.4999987499995
.nodeset v(xt1.n2991765)=2.4999987499995
.nodeset v(xt1.n2991807)=62.4999987499995
.nodeset v(xt1.n2991809)=2.4999987499995
.nodeset v(xt1.n2991811)=2.4999987499995
.nodeset v(xt1.n2991831)=2.49999874999964
.nodeset v(xt1.n2991837)=2.49999874999964
.nodeset v(xt1.n2991849)=-57.5000012500005
.nodeset v(xt1.n2991901)=152.499998749999
.nodeset v(xt1.n2991905)=2.49999874999964
.nodeset v(xt1.n2991907)=2.49999874999964
.nodeset v(xt1.n2991925)=2.49999874999964
.nodeset v(xt1.n2991931)=2.49999874999964
.nodeset v(xt1.n2991943)=-147.500001250001
.nodeset v(xt1.n2991969)=2.50249712908504
.nodeset v(xt1.n2991997)=4.98504691954498
.nodeset v(xt1.n2992001)=0.0234049940480601
.nodeset v(xt1.n2992029)=0.0234049940480601
.nodeset v(xt1.n2992033)=4.98504691954498
.nodeset v(xt1.n2992093)=2.49999869488949
.nodeset v(xt1.n2992099)=2.4999986948895
.nodeset v(xt1.n2992105)=2.4999987499995
.nodeset v(xt1.n2992151)=2.50249769531701
.nodeset v(xt1.n2992163)=2.50249627512652
.nodeset v(xt1.n2992235)=2.50249627512652
.nodeset v(xt1.n2992267)=-52.4975033695619
.nodeset v(xt1.n2992287)=57.5024965202181
.nodeset v(xt1.n2992295)=-52.4975034246719
.nodeset v(xt1.n2992299)=-52.4975033695619
.nodeset v(xt1.n2992323)=57.5024965202181
.nodeset v(xt1.n2992331)=57.5024965753281
.nodeset v(xt1.n2992375)=2.4999987499995
.nodeset v(xt1.n2992397)=4.9999974974989
.nodeset v(xt1.n2992413)=2.50249884429792e-06
.nodeset v(xt1.n3201092)=2.57127789080336
.nodeset v(xt1.n3294524)=2.50249657532836
.nodeset v(xt1.n3294618)=2.50249657532812
.nodeset v(xt1.n3294626)=2.57127788669633
.nodeset v(xt1.n3294630)=2.53394119800134
.nodeset v(xt1.n3294682)=2.57120306933848
.nodeset v(xt1.n3294772)=2.49999875004402
.nodeset v(xt1.n3294776)=2.49999874999962
.nodeset v(xt1.n3827259)=2.57126396203797
.nodeset v(xt1.n3828449)=2.50005571659585
.nodeset v(xt1.n3850714)=2.50103724946989
.nodeset v(xt1.n3850724)=2.50000189746958
.nodeset v(xt1.n4031911)=2.50249712908504
.nodeset v(xt1.n4243633)=1.18600073413911
.nodeset v(xt1.n4736080)=2.5046480183334
.nodeset v(xt1.n4745674)=2.57127789080336
.nodeset v(xt1.n4747399)=2.57127789080336
.nodeset v(xt1.n4749239)=2.57127789080336
.nodeset v(xt1.n4796554)=2.57127789080336
.nodeset v(xt1.n4796572)=2.57127789080337
.nodeset v(xt1.n4797748)=2.57127265392579
.nodeset v(xt1.n4797760)=2.51890387807987
.nodeset v(xt1.n4798545)=2.57127108286251
.nodeset v(xt1.n4800105)=2.57127108286251
.nodeset v(xt1.n4809008)=2.49999875004403
.nodeset v(xt1.n4817896)=2.50103741511577
.nodeset v(xt1.n47456861)=2.57127789080336
.nodeset v(xt1.n47492651)=2.57127789080336
.nodeset v(xt1.n47965841)=2.57127789080337
.nodeset v(xt1.n48001371)=2.57127108286251
.nodeset v(xt1.sw_ol_opa4388)=2.4999987499995
.nodeset v(xt1.v11)=2.49999869488949
.nodeset v(xt1.v12)=2.4999986948895
.nodeset v(xt1.vcc_b)=4.9999974999989
.nodeset v(xt1.vcc_clp)=4.98504691705993
.nodeset v(xt1.vclp)=2.50249657532812
.nodeset v(xt1.vee_b)=2.49999884805042e-06
.nodeset v(xt1.vee_clp)=0.0234049965246538
.nodeset v(xt1.vimon)=2.50249769531701
.nodeset v(xt1.vout_s)=2.50249627512652
.nodeset v(xt1.vsense)=2.50249712908504
.nodeset v(xt1.x_u4.e1_int1)=-4.67e-06
.nodeset v(xt1.x_u6.g1_int1)=2.89041610024299e-06
.nodeset v(xt1.x_u10.gvo+_int1)=0
.nodeset v(xt1.x_u10.gvo-_int1)=0
.nodeset v(xt1.x_u11.gvo+_int1)=0
.nodeset v(xt1.x_u11.gvo-_int1)=0
.nodeset v(xt1.x_u12.gvo+_int1)=0
.nodeset v(xt1.x_u12.gvo-_int1)=0
.nodeset v(xt1.x_u16.gsw+_int1)=0
.nodeset v(xt1.x_u18.g1_int1)=1.49505805717949e-05
.nodeset v(xt1.x_u18.g1_int2)=0.00249894531750971
.nodeset v(xt1.x_u19.g1_int1)=2.34024940486586e-05
.nodeset v(xt1.x_u19.g1_int2)=-0.00249894531750971
.nodeset v(xt1.x_u22.g1_int1)=-1.4432899320127e-13
.nodeset v(xt1.x_u23.g1_int1)=0
.nodeset v(xt1.x_u26.g1_int1)=2.49894531750968e-06
.nodeset v(xt1.x_u27.g1_int1)=0
.nodeset v(xt1.x_u30.g1_int1)=1.04770792735964e-14
.nodeset v(xt1.x_u31.g1_int1)=2.498380391458e-09
.nodeset v(xt1.x_u32.g1_int1)=0.071208245442449
.nodeset v(xt1.x_u35.g1_int1)=1.4432899320127e-13
.nodeset v(xt1.x_u38.3)=0
.nodeset v(xt1.x_u38.5)=0
.nodeset v(xt1.x_u39.3)=0
.nodeset v(xt1.x_u39.5)=0
.nodeset v(xt1.x_u40.5)=0
.nodeset v(xt2.cl_clamp)=2.50249656750236
.nodeset v(xt2.clamp)=2.50249712134246
.nodeset v(xt2.claw_clamp)=2.50249656764658
.nodeset v(xt2.esdn)=2.50000164006347
.nodeset v(xt2.esdp)=2.50000001536652
.nodeset v(xt2.mid)=2.4999987499995
.nodeset v(xt2.n2991553)=2.49999874999962
.nodeset v(xt2.n2991555)=2.49999534536652
.nodeset v(xt2.n2991563)=2.49999534517673
.nodeset v(xt2.n2991573)=2.50000001536652
.nodeset v(xt2.n2991579)=2.49999560298179
.nodeset v(xt2.n2991581)=2.50000189797161
.nodeset v(xt2.n2991583)=2.49999534517673
.nodeset v(xt2.n2991587)=2.50000164016656
.nodeset v(xt2.n2991619)=2.50000164006347
.nodeset v(xt2.n2991623)=5.09999749999889
.nodeset v(xt2.n2991635)=-0.099997500001152
.nodeset v(xt2.n2991643)=2.5000016401667
.nodeset v(xt2.n2991657)=2.5000016401667
.nodeset v(xt2.n2991667)=2.49999875994622
.nodeset v(xt2.n2991729)=2.49999874999964
.nodeset v(xt2.n2991741)=2.49999874999964
.nodeset v(xt2.n2991763)=2.49999874999964
.nodeset v(xt2.n2991765)=2.49999874999964
.nodeset v(xt2.n2991807)=62.4999987499995
.nodeset v(xt2.n2991809)=2.49999874999964
.nodeset v(xt2.n2991811)=2.49999874999964
.nodeset v(xt2.n2991831)=2.4999987499995
.nodeset v(xt2.n2991837)=2.4999987499995
.nodeset v(xt2.n2991849)=-57.5000012500005
.nodeset v(xt2.n2991901)=152.499998749999
.nodeset v(xt2.n2991905)=2.49999874999964
.nodeset v(xt2.n2991907)=2.49999874999964
.nodeset v(xt2.n2991925)=2.4999987499995
.nodeset v(xt2.n2991931)=2.4999987499995
.nodeset v(xt2.n2991943)=-147.500001250001
.nodeset v(xt2.n2991969)=2.50249712140163
.nodeset v(xt2.n2991997)=4.9850469195538
.nodeset v(xt2.n2992001)=0.0234049940664729
.nodeset v(xt2.n2992029)=0.0234049940664729
.nodeset v(xt2.n2992033)=4.9850469195538
.nodeset v(xt2.n2992093)=2.49999869488949
.nodeset v(xt2.n2992099)=2.4999986948895
.nodeset v(xt2.n2992105)=2.4999987499995
.nodeset v(xt2.n2992151)=2.50249769404645
.nodeset v(xt2.n2992163)=2.50249626730121
.nodeset v(xt2.n2992235)=2.50249626730121
.nodeset v(xt2.n2992267)=-52.4975033773876
.nodeset v(xt2.n2992287)=57.5024965123924
.nodeset v(xt2.n2992295)=-52.4975034324976
.nodeset v(xt2.n2992299)=-52.4975033773876
.nodeset v(xt2.n2992323)=57.5024965123924
.nodeset v(xt2.n2992331)=57.5024965675024
.nodeset v(xt2.n2992375)=2.4999987499995
.nodeset v(xt2.n2992397)=4.9999974974989
.nodeset v(xt2.n2992413)=2.50249884429792e-06
.nodeset v(xt2.n3201092)=2.57127778242069
.nodeset v(xt2.n3294524)=2.50249656764665
.nodeset v(xt2.n3294618)=2.50249656750236
.nodeset v(xt2.n3294626)=2.57127777831366
.nodeset v(xt2.n3294630)=2.53394114639054
.nodeset v(xt2.n3294682)=2.57120296106905
.nodeset v(xt2.n3294772)=2.49999875004403
.nodeset v(xt2.n3294776)=2.49999874999962
.nodeset v(xt2.n3827259)=2.57126385367648
.nodeset v(xt2.n3828449)=2.50005571650923
.nodeset v(xt2.n3850714)=2.50103724946989
.nodeset v(xt2.n3850724)=2.50000189746958
.nodeset v(xt2.n4031911)=2.50249712140163
.nodeset v(xt2.n4243633)=1.18600073413911
.nodeset v(xt2.n4736080)=2.50464800403523
.nodeset v(xt2.n4745674)=2.57127778242069
.nodeset v(xt2.n4747399)=2.57127778242069
.nodeset v(xt2.n4749239)=2.57127778242069
.nodeset v(xt2.n4796554)=2.57127778242069
.nodeset v(xt2.n4796572)=2.5712777824207
.nodeset v(xt2.n4797748)=2.57127254555108
.nodeset v(xt2.n4797760)=2.5189038493339
.nodeset v(xt2.n4798545)=2.57127097449019
.nodeset v(xt2.n4800105)=2.57127097449019
.nodeset v(xt2.n4809008)=2.49999875004403
.nodeset v(xt2.n4817896)=2.50103741511577
.nodeset v(xt2.n47456861)=2.57127778242069
.nodeset v(xt2.n47492651)=2.57127778242069
.nodeset v(xt2.n47965841)=2.5712777824207
.nodeset v(xt2.n48001371)=2.57127097449019
.nodeset v(xt2.sw_ol_opa4388)=2.4999987499995
.nodeset v(xt2.v11)=2.49999869488949
.nodeset v(xt2.v12)=2.4999986948895
.nodeset v(xt2.vcc_b)=4.9999974999989
.nodeset v(xt2.vcc_clp)=4.98504691706875
.nodeset v(xt2.vclp)=2.50249656750237
.nodeset v(xt2.vee_b)=2.49999884805042e-06
.nodeset v(xt2.vee_clp)=0.0234049965430667
.nodeset v(xt2.vimon)=2.50249769404645
.nodeset v(xt2.vout_s)=2.50249626730121
.nodeset v(xt2.vsense)=2.50249712140163
.nodeset v(xt2.x_u4.e1_int1)=-4.67e-06
.nodeset v(xt2.x_u6.g1_int1)=2.89016705989909e-06
.nodeset v(xt2.x_u10.gvo+_int1)=0
.nodeset v(xt2.x_u10.gvo-_int1)=0
.nodeset v(xt2.x_u11.gvo+_int1)=0
.nodeset v(xt2.x_u11.gvo-_int1)=0
.nodeset v(xt2.x_u12.gvo+_int1)=0
.nodeset v(xt2.x_u12.gvo-_int1)=0
.nodeset v(xt2.x_u16.gsw+_int1)=0
.nodeset v(xt2.x_u18.g1_int1)=1.49505805629724e-05
.nodeset v(xt2.x_u18.g1_int2)=0.0024989440469545
.nodeset v(xt2.x_u19.g1_int1)=2.34024940670714e-05
.nodeset v(xt2.x_u19.g1_int2)=-0.0024989440469545
.nodeset v(xt2.x_u22.g1_int1)=1.4432899320127e-13
.nodeset v(xt2.x_u23.g1_int1)=1.4432899320127e-13
.nodeset v(xt2.x_u26.g1_int1)=2.49894404695441e-06
.nodeset v(xt2.x_u27.g1_int1)=0
.nodeset v(xt2.x_u30.g1_int1)=1.03232309853207e-14
.nodeset v(xt2.x_u31.g1_int1)=2.49851717093463e-09
.nodeset v(xt2.x_u32.g1_int1)=0.0712081371671047
.nodeset v(xt2.x_u35.g1_int1)=0
.nodeset v(xt2.x_u38.3)=0
.nodeset v(xt2.x_u38.5)=0
.nodeset v(xt2.x_u39.3)=0
.nodeset v(xt2.x_u39.5)=0
.nodeset v(xt2.x_u40.5)=0
.nodeset v(xt3.cl_clamp)=2.50249656764665
.nodeset v(xt3.clamp)=2.50249712134246
.nodeset v(xt3.claw_clamp)=2.50249656764665
.nodeset v(xt3.esdn)=2.50000164006347
.nodeset v(xt3.esdp)=2.50000001536652
.nodeset v(xt3.mid)=2.4999987499995
.nodeset v(xt3.n2991553)=2.49999874999962
.nodeset v(xt3.n2991555)=2.49999534536652
.nodeset v(xt3.n2991563)=2.49999534517673
.nodeset v(xt3.n2991573)=2.50000001536652
.nodeset v(xt3.n2991579)=2.49999560298179
.nodeset v(xt3.n2991581)=2.50000189797161
.nodeset v(xt3.n2991583)=2.49999534517673
.nodeset v(xt3.n2991587)=2.50000164016656
.nodeset v(xt3.n2991619)=2.50000164006347
.nodeset v(xt3.n2991623)=5.0999974999989
.nodeset v(xt3.n2991635)=-0.099997500001152
.nodeset v(xt3.n2991643)=2.50000164016656
.nodeset v(xt3.n2991657)=2.50000164016656
.nodeset v(xt3.n2991667)=2.49999875994564
.nodeset v(xt3.n2991729)=2.4999987499995
.nodeset v(xt3.n2991741)=2.4999987499995
.nodeset v(xt3.n2991763)=2.4999987499995
.nodeset v(xt3.n2991765)=2.4999987499995
.nodeset v(xt3.n2991807)=62.4999987499995
.nodeset v(xt3.n2991809)=2.49999874999964
.nodeset v(xt3.n2991811)=2.49999874999964
.nodeset v(xt3.n2991831)=2.49999874999964
.nodeset v(xt3.n2991837)=2.49999874999964
.nodeset v(xt3.n2991849)=-57.5000012500005
.nodeset v(xt3.n2991901)=152.499998749999
.nodeset v(xt3.n2991905)=2.49999874999964
.nodeset v(xt3.n2991907)=2.49999874999964
.nodeset v(xt3.n2991925)=2.49999874999964
.nodeset v(xt3.n2991931)=2.49999874999964
.nodeset v(xt3.n2991943)=-147.500001250001
.nodeset v(xt3.n2991969)=2.50249712140163
.nodeset v(xt3.n2991997)=4.98504691955364
.nodeset v(xt3.n2992001)=0.0234049940661224
.nodeset v(xt3.n2992029)=0.0234049940661224
.nodeset v(xt3.n2992033)=4.98504691955364
.nodeset v(xt3.n2992093)=2.49999869488949
.nodeset v(xt3.n2992099)=2.4999986948895
.nodeset v(xt3.n2992105)=2.4999987499995
.nodeset v(xt3.n2992151)=2.50249769407064
.nodeset v(xt3.n2992163)=2.50249626744549
.nodeset v(xt3.n2992235)=2.50249626744549
.nodeset v(xt3.n2992267)=-52.4975033772433
.nodeset v(xt3.n2992287)=57.5024965125367
.nodeset v(xt3.n2992295)=-52.4975034323533
.nodeset v(xt3.n2992299)=-52.4975033772433
.nodeset v(xt3.n2992323)=57.5024965125367
.nodeset v(xt3.n2992331)=57.5024965676467
.nodeset v(xt3.n2992375)=2.4999987499995
.nodeset v(xt3.n2992397)=4.9999974974989
.nodeset v(xt3.n2992413)=2.50249884429792e-06
.nodeset v(xt3.n3201092)=2.57127778439975
.nodeset v(xt3.n3294524)=2.50249656764665
.nodeset v(xt3.n3294618)=2.50249656764665
.nodeset v(xt3.n3294626)=2.57127778029272
.nodeset v(xt3.n3294630)=2.53394114733295
.nodeset v(xt3.n3294682)=2.57120296304629
.nodeset v(xt3.n3294772)=2.49999875004402
.nodeset v(xt3.n3294776)=2.49999874999962
.nodeset v(xt3.n3827259)=2.57126385565515
.nodeset v(xt3.n3828449)=2.50005571651081
.nodeset v(xt3.n3850714)=2.50103724946989
.nodeset v(xt3.n3850724)=2.50000189746958
.nodeset v(xt3.n4031911)=2.50249712140163
.nodeset v(xt3.n4243633)=1.18600073413911
.nodeset v(xt3.n4736080)=2.50464800403523
.nodeset v(xt3.n4745674)=2.57127778439975
.nodeset v(xt3.n4747399)=2.57127778439975
.nodeset v(xt3.n4749239)=2.57127778439975
.nodeset v(xt3.n4796554)=2.57127778439975
.nodeset v(xt3.n4796572)=2.57127778439976
.nodeset v(xt3.n4797748)=2.57127254752999
.nodeset v(xt3.n4797760)=2.5189038498588
.nodeset v(xt3.n4798545)=2.57127097646906
.nodeset v(xt3.n4800105)=2.57127097646906
.nodeset v(xt3.n4809008)=2.49999875004403
.nodeset v(xt3.n4817896)=2.50103741511577
.nodeset v(xt3.n47456861)=2.57127778439975
.nodeset v(xt3.n47492651)=2.57127778439975
.nodeset v(xt3.n47965841)=2.57127778439976
.nodeset v(xt3.n48001371)=2.57127097646906
.nodeset v(xt3.sw_ol_opa4388)=2.4999987499995
.nodeset v(xt3.v11)=2.49999869488949
.nodeset v(xt3.v12)=2.4999986948895
.nodeset v(xt3.vcc_b)=4.9999974999989
.nodeset v(xt3.vcc_clp)=4.98504691706859
.nodeset v(xt3.vclp)=2.50249656764665
.nodeset v(xt3.vee_b)=2.49999884805042e-06
.nodeset v(xt3.vee_clp)=0.0234049965427162
.nodeset v(xt3.vimon)=2.50249769407064
.nodeset v(xt3.vout_s)=2.50249626744549
.nodeset v(xt3.vsense)=2.50249712140163
.nodeset v(xt3.x_u4.e1_int1)=-4.67e-06
.nodeset v(xt3.x_u6.g1_int1)=2.89016705901091e-06
.nodeset v(xt3.x_u10.gvo+_int1)=0
.nodeset v(xt3.x_u10.gvo-_int1)=0
.nodeset v(xt3.x_u11.gvo+_int1)=0
.nodeset v(xt3.x_u11.gvo-_int1)=0
.nodeset v(xt3.x_u12.gvo+_int1)=0
.nodeset v(xt3.x_u12.gvo-_int1)=0
.nodeset v(xt3.x_u16.gsw+_int1)=0
.nodeset v(xt3.x_u18.g1_int1)=1.49505805631404e-05
.nodeset v(xt3.x_u18.g1_int2)=0.00249894407114137
.nodeset v(xt3.x_u19.g1_int1)=2.34024940667209e-05
.nodeset v(xt3.x_u19.g1_int2)=-0.00249894407114137
.nodeset v(xt3.x_u22.g1_int1)=0
.nodeset v(xt3.x_u23.g1_int1)=0
.nodeset v(xt3.x_u26.g1_int1)=2.49894407114122e-06
.nodeset v(xt3.x_u27.g1_int1)=0
.nodeset v(xt3.x_u30.g1_int1)=1.03087568863181e-14
.nodeset v(xt3.x_u31.g1_int1)=2.49837284194143e-09
.nodeset v(xt3.x_u32.g1_int1)=0.071208139144801
.nodeset v(xt3.x_u35.g1_int1)=0
.nodeset v(xt3.x_u38.3)=0
.nodeset v(xt3.x_u38.5)=0
.nodeset v(xt3.x_u39.3)=0
.nodeset v(xt3.x_u39.5)=0
.nodeset v(xt3.x_u40.5)=0
.nodeset v(e0)=2.50000016912203
.nodeset v(e1)=2.24999993888856
.nodeset v(e2)=2.50000164001882
.nodeset v(e3)=2.50000163999004
.nodeset v(e4)=2.50000164025227
.nodeset v(e5)=2.50000163999066
.nodeset v(e6)=2.50000164006316
.nodeset v(e7)=2.50000164031052
.nodeset v(e8)=2.50000164006316
.nodeset v(e9)=2.50000164006316
VP0 src0 0 DC 0 AC 0
CPORT0 src0 e0 1u
VP1 src1 0 DC 0 AC 0
CPORT1 src1 e1 1u
VP2 src2 0 DC 0 AC 0
CPORT2 src2 e2 1u
VP3 src3 0 DC 0 AC 0
CPORT3 src3 e3 1u
VP4 src4 0 DC 0 AC 0
CPORT4 src4 e4 1u
VP5 src5 0 DC 0 AC 0
CPORT5 src5 e5 1u
VP6 src6 0 DC 0 AC 0
CPORT6 src6 e6 1u
VP7 src7 0 DC 0 AC 0
CPORT7 src7 e7 1u
VP8 src8 0 DC 0 AC 0
CPORT8 src8 e8 1u
VP9 src9 0 DC 0 AC 0
CPORT9 src9 e9 1u
VP10 src10 0 DC 0 AC 1
CPORT10 src10 cmfb 1u
VP11 src11 0 DC 0 AC 0
CPORT11 src11 exfb 1u
VP12 src12 0 DC 0 AC 0
CPORT12 src12 fb0 1u
VP13 src13 0 DC 0 AC 0
CPORT13 src13 fb1 1u
VP14 src14 0 DC 0 AC 0
CPORT14 src14 fb2 1u
VP15 src15 0 DC 0 AC 0
CPORT15 src15 fb3 1u
VP16 src16 0 DC 0 AC 0
CPORT16 src16 minus0 1u
VP17 src17 0 DC 0 AC 0
CPORT17 src17 minus1 1u
VP18 src18 0 DC 0 AC 0
CPORT18 src18 minus2 1u
VP19 src19 0 DC 0 AC 0
CPORT19 src19 minus3 1u
.save all
.control
set filetype=ascii
set wr_singlescale
set wr_vecnames
set numdgt=15
op
write op.raw all
ac dec 80 1 300meg
let ip0=-i(VP0)
let ip1=-i(VP1)
let ip2=-i(VP2)
let ip3=-i(VP3)
let ip4=-i(VP4)
let ip5=-i(VP5)
let ip6=-i(VP6)
let ip7=-i(VP7)
let ip8=-i(VP8)
let ip9=-i(VP9)
let ip10=-i(VP10)
let ip11=-i(VP11)
let ip12=-i(VP12)
let ip13=-i(VP13)
let ip14=-i(VP14)
let ip15=-i(VP15)
let ip16=-i(VP16)
let ip17=-i(VP17)
let ip18=-i(VP18)
let ip19=-i(VP19)
wrdata ac.txt ip0 ip1 ip2 ip3 ip4 ip5 ip6 ip7 ip8 ip9 ip10 ip11 ip12 ip13 ip14 ip15 ip16 ip17 ip18 ip19 v(e0) v(e1) v(e2) v(e3) v(e4) v(e5) v(e6) v(e7) v(e8) v(e9) v(cmfb) v(exfb) v(fb0) v(fb1) v(fb2) v(fb3) v(minus0) v(minus1) v(minus2) v(minus3)
quit
.endc
.end
